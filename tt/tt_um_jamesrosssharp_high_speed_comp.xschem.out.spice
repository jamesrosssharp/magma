.include /opt/pdk/sky130A/libs.ref/sky130_fd_sc_hd/spice/sky130_fd_sc_hd.spice

** sch_path: /home/jrsharp/code/magma/xschem/tt/tt_um_jamesrosssharp_high_speed_comp.sch
.subckt tt_um_jamesrosssharp_high_speed_comp clk ena rst_n ua[0] ua[1] ua[2] ua[3] ua[4] ua[5] ua[6]
+ ua[7] ui_in[0] ui_in[1] ui_in[2] ui_in[3] ui_in[4] ui_in[5] ui_in[6] ui_in[7] uio_in[0] uio_in[1]
+ uio_in[2] uio_in[3] uio_in[4] uio_in[5] uio_in[6] uio_in[7] uio_oe[0] uio_oe[1] uio_oe[2] uio_oe[3] uio_oe[4]
+ uio_oe[5] uio_oe[6] uio_oe[7] uio_out[0] uio_out[1] uio_out[2] uio_out[3] uio_out[4] uio_out[5] uio_out[6]
+ uio_out[7] uo_out[0] uo_out[1] uo_out[2] uo_out[3] uo_out[4] uo_out[5] uo_out[6] uo_out[7] VDPWR VGND
*.PININFO clk:I ena:I rst_n:I ua[0]:B ua[1]:B ua[2]:B ua[3]:B ua[4]:B ua[5]:B ua[6]:B ua[7]:B
*+ ui_in[0]:I ui_in[1]:I ui_in[2]:I ui_in[3]:I ui_in[4]:I ui_in[5]:I ui_in[6]:I ui_in[7]:I uio_in[0]:I
*+ uio_in[1]:I uio_in[2]:I uio_in[3]:I uio_in[4]:I uio_in[5]:I uio_in[6]:I uio_in[7]:I uio_oe[0]:O uio_oe[1]:O
*+ uio_oe[2]:O uio_oe[3]:O uio_oe[4]:O uio_oe[5]:O uio_oe[6]:O uio_oe[7]:O uio_out[0]:B uio_out[1]:B uio_out[2]:B
*+ uio_out[3]:B uio_out[4]:B uio_out[5]:B uio_out[6]:B uio_out[7]:B uo_out[0]:O uo_out[1]:O uo_out[2]:O uo_out[3]:O
*+ uo_out[4]:O uo_out[5]:O uo_out[6]:O uo_out[7]:O VDPWR:I VGND:I
x1 ua[0] VDPWR VGND ui_in[0] clk_prime net1 ua[1] 1bit_am
x2 net6 clk_prime ua[0] net14 net7 VDPWR VGND net8 net9 net13 net12 net11 net10 net3 flash_converter
x3 VGND VGND VDPWR VDPWR uio_oe[0] net15 sky130_fd_sc_hd__conb_1
x4 VGND VGND VDPWR VDPWR uio_oe[1] net16 sky130_fd_sc_hd__conb_1
x5 VGND VGND VDPWR VDPWR uio_oe[2] net17 sky130_fd_sc_hd__conb_1
x6 VGND VGND VDPWR VDPWR uio_oe[3] net18 sky130_fd_sc_hd__conb_1
x7 VGND VGND VDPWR VDPWR uio_oe[4] net19 sky130_fd_sc_hd__conb_1
x8 VGND VGND VDPWR VDPWR uio_oe[5] net20 sky130_fd_sc_hd__conb_1
x9 VGND VGND VDPWR VDPWR uio_oe[6] net21 sky130_fd_sc_hd__conb_1
x10 VGND VGND VDPWR VDPWR uio_oe[7] net22 sky130_fd_sc_hd__conb_1
x11 clk_prime ua[0] ua[1] VDPWR net2 VGND high_speed_comp_top
x12 VGND VGND VDPWR VDPWR net23 uo_out[2] sky130_fd_sc_hd__conb_1
x13 VGND VGND VDPWR VDPWR net24 uo_out[3] sky130_fd_sc_hd__conb_1
x14 VGND VGND VDPWR VDPWR net25 uo_out[4] sky130_fd_sc_hd__conb_1
x15 VGND VGND VDPWR VDPWR net26 uo_out[5] sky130_fd_sc_hd__conb_1
x16 VGND VGND VDPWR VDPWR net27 uo_out[6] sky130_fd_sc_hd__conb_1
x17 VGND VGND VDPWR VDPWR net28 uo_out[7] sky130_fd_sc_hd__conb_1
XR11 net6 VDPWR VGND sky130_fd_pr__res_high_po_1p41 L=1.41 mult=1 m=1
XR1 net3 net4 VGND sky130_fd_pr__res_high_po_1p41 L=1.41 mult=1 m=1
XR2 net4 net5 VGND sky130_fd_pr__res_high_po_1p41 L=1.41 mult=1 m=1
XR3 net5 VGND VGND sky130_fd_pr__res_high_po_1p41 L=1.41 mult=1 m=1
x18 clk VGND VGND VDPWR VDPWR clk_prime sky130_fd_sc_hd__clkbuf_16
x19 VGND VGND VDPWR VDPWR sky130_fd_sc_hd__decap_3
x20 VGND VDPWR sky130_fd_sc_hd__tapvpwrvgnd_1
x21 net2 VGND VGND VDPWR VDPWR uo_out[1] sky130_fd_sc_hd__buf_4
x22 net1 VGND VGND VDPWR VDPWR uo_out[0] sky130_fd_sc_hd__buf_4
x23 VGND VGND VDPWR VDPWR sky130_fd_sc_hd__decap_3
x24 VGND VDPWR sky130_fd_sc_hd__tapvpwrvgnd_1
x25 VGND VGND VDPWR VDPWR sky130_fd_sc_hd__decap_3
x26 VGND VDPWR sky130_fd_sc_hd__tapvpwrvgnd_1
x27 net14 VGND VGND VDPWR VDPWR uio_out[0] sky130_fd_sc_hd__buf_4
x28 net7 VGND VGND VDPWR VDPWR uio_out[1] sky130_fd_sc_hd__buf_4
x29 net8 VGND VGND VDPWR VDPWR uio_out[2] sky130_fd_sc_hd__buf_4
x31 net13 VGND VGND VDPWR VDPWR uio_out[4] sky130_fd_sc_hd__buf_4
x32 net12 VGND VGND VDPWR VDPWR uio_out[5] sky130_fd_sc_hd__buf_4
x33 net11 VGND VGND VDPWR VDPWR uio_out[6] sky130_fd_sc_hd__buf_4
x34 net10 VGND VGND VDPWR VDPWR uio_out[7] sky130_fd_sc_hd__buf_4
x30 net9 VGND VGND VDPWR VDPWR uio_out[3] sky130_fd_sc_hd__buf_4
x35 VGND VGND VDPWR VDPWR sky130_fd_sc_hd__decap_3
x36 VGND VDPWR sky130_fd_sc_hd__tapvpwrvgnd_1
x37 VGND VGND VDPWR VDPWR sky130_fd_sc_hd__decap_3
x38 VGND VDPWR sky130_fd_sc_hd__tapvpwrvgnd_1
x39 VGND VGND VDPWR VDPWR sky130_fd_sc_hd__decap_3
x40 VGND VDPWR sky130_fd_sc_hd__tapvpwrvgnd_1
.ends

* expanding   symbol:  1bit_am.sym # of pins=7
** sym_path: /home/jrsharp/code/magma/xschem/tt/1bit_am.sym
** sch_path: /home/jrsharp/code/magma/xschem/tt/1bit_am.sch
.subckt 1bit_am VIN VDD VSS PWM_IN CLK VOUT VIN_MINUS
*.PININFO VDD:I VSS:I CLK:I VIN:I VOUT:O PWM_IN:I VIN_MINUS:I
x1 CLK NET_IN VIN_MINUS VDD VOUT VSS high_speed_comp_top
XR2 net2 VIN_MINUS VSS sky130_fd_pr__res_xhigh_po_0p35 L=30 mult=1 m=1
XR3 VDD net3 VSS sky130_fd_pr__res_xhigh_po_0p35 L=20 mult=1 m=1
XR4 net3 NET_IN VSS sky130_fd_pr__res_xhigh_po_0p35 L=20 mult=1 m=1
XR5 NET_IN net4 VSS sky130_fd_pr__res_xhigh_po_0p35 L=20 mult=1 m=1
XR6 net4 VSS VSS sky130_fd_pr__res_xhigh_po_0p35 L=20 mult=1 m=1
XC1 VIN NET_IN sky130_fd_pr__cap_mim_m3_1 W=10 L=10 m=20
XC2 VIN_MINUS VSS sky130_fd_pr__cap_mim_m3_1 W=10 L=10 m=20
x4 VSS VSS VDD VDD sky130_fd_sc_hd__decap_3
x5 VSS VSS VDD VDD sky130_fd_sc_hd__decap_3
x6 VSS VDD sky130_fd_sc_hd__tapvpwrvgnd_1
x7 VSS VDD sky130_fd_sc_hd__tapvpwrvgnd_1
XR1 net5 net6 VSS sky130_fd_pr__res_xhigh_po_0p35 L=30 mult=1 m=1
x3 PWM_IN VSS VSS VDD VDD net1 sky130_fd_sc_hd__inv_1
XR7 net6 net7 VSS sky130_fd_pr__res_xhigh_po_0p35 L=30 mult=1 m=1
XR8 net7 net2 VSS sky130_fd_pr__res_xhigh_po_0p35 L=30 mult=1 m=1
x2 net1 VSS VSS VDD VDD net5 sky130_fd_sc_hd__inv_1
.ends

* expanding   symbol:  flash_converter.sym # of pins=14
** sym_path: /home/jrsharp/code/magma/xschem/tt/flash_converter.sym
** sch_path: /home/jrsharp/code/magma/xschem/tt/flash_converter.sch
.subckt flash_converter RES_TOP CLK VIN O0 O1 VDD VSS O2 O3 O4 O5 O6 O7 RES_OUT
*.PININFO VIN:I RES_TOP:I RES_OUT:O O0:O O1:O O2:O O3:O O4:O O5:O O6:O O7:O CLK:I VDD:I VSS:I
x1 CLK VIN RES_TOP VDD O0 VSS high_speed_comp_top
x2 CLK VIN net1 VDD O1 VSS high_speed_comp_top
x3 CLK VIN net2 VDD O2 VSS high_speed_comp_top
x4 CLK VIN net3 VDD O3 VSS high_speed_comp_top
x5 CLK VIN net4 VDD O4 VSS high_speed_comp_top
x6 CLK VIN net5 VDD O5 VSS high_speed_comp_top
x7 CLK VIN net6 VDD O6 VSS high_speed_comp_top
x8 CLK VIN net7 VDD O7 VSS high_speed_comp_top
XR1 net1 RES_TOP VSS sky130_fd_pr__res_high_po_1p41 L=1.41 mult=1 m=1
XR2 net2 net1 VSS sky130_fd_pr__res_high_po_1p41 L=1.41 mult=1 m=1
XR3 net3 net2 VSS sky130_fd_pr__res_high_po_1p41 L=1.41 mult=1 m=1
XR4 net4 net3 VSS sky130_fd_pr__res_high_po_1p41 L=1.41 mult=1 m=1
XR5 net5 net4 VSS sky130_fd_pr__res_high_po_1p41 L=1.41 mult=1 m=1
XR6 net6 net5 VSS sky130_fd_pr__res_high_po_1p41 L=1.41 mult=1 m=1
XR7 net7 net6 VSS sky130_fd_pr__res_high_po_1p41 L=1.41 mult=1 m=1
XR8 RES_OUT net7 VSS sky130_fd_pr__res_high_po_1p41 L=1.41 mult=1 m=1
XR9 net8 net9 VSS sky130_fd_pr__res_high_po_1p41 L=1.41 mult=1 m=1
XR10 net10 net11 VSS sky130_fd_pr__res_high_po_1p41 L=1.41 mult=1 m=1
XR11 net12 net13 VSS sky130_fd_pr__res_high_po_1p41 L=1.41 mult=1 m=1
XR12 net14 net15 VSS sky130_fd_pr__res_high_po_1p41 L=1.41 mult=1 m=1
.ends

* expanding   symbol:  high_speed_comp_top.sym # of pins=6
** sym_path: /home/jrsharp/code/magma/xschem/tt/high_speed_comp_top.sym
** sch_path: /home/jrsharp/code/magma/xschem/tt/high_speed_comp_top.sch
.subckt high_speed_comp_top CLK VINP VINN VDD COMP_OUT VSS
*.PININFO VINP:I VINN:I CLK:I COMP_OUT:O VDD:I VSS:I
x1 VDD CLK_PRIME net1 net2 VSS VINP VINN strong_arm_latch
x2 VDD net1 net2 VOUT VSS post_amplifier
x3 CLK VOUT VSS VSS VDD VDD COMP_OUT sky130_fd_sc_hd__dfxtp_2
x4 CLK VSS VSS VDD VDD CLK_PRIME sky130_fd_sc_hd__clkinv_4
x5 VSS VSS VDD VDD sky130_fd_sc_hd__decap_3
x7 VSS VSS VDD VDD sky130_fd_sc_hd__decap_3
x9 VSS VDD sky130_fd_sc_hd__tapvpwrvgnd_1
x6 VSS VDD sky130_fd_sc_hd__tapvpwrvgnd_1
x8 VSS VDD sky130_fd_sc_hd__tapvpwrvgnd_1
.ends

* expanding   symbol:  strong_arm_latch.sym # of pins=7
** sym_path: /home/jrsharp/code/magma/xschem/tt/strong_arm_latch.sym
** sch_path: /home/jrsharp/code/magma/xschem/tt/strong_arm_latch.sch
.subckt strong_arm_latch VDD CLK VOUT_PLUS VOUT_MINUS VSS VINP VINN
*.PININFO VSS:I VDD:I CLK:I VINP:I VINN:I VOUT_MINUS:O VOUT_PLUS:O
XM1 net2 VINP net1 VSS sky130_fd_pr__nfet_01v8_lvt L=1 W=5 nf=1 m=1
XM2 net3 VINN net1 VSS sky130_fd_pr__nfet_01v8_lvt L=1 W=5 nf=1 m=1
XM3 net1 CLK VSS VSS sky130_fd_pr__nfet_01v8_lvt L=1 W=5 nf=1 m=1
XM4 VOUT_PLUS VOUT_MINUS net2 VSS sky130_fd_pr__nfet_01v8 L=0.15 W=1 nf=1 m=1
XM5 VOUT_MINUS VOUT_PLUS net3 VSS sky130_fd_pr__nfet_01v8 L=0.15 W=1 nf=1 m=1
XM6 VOUT_PLUS VOUT_MINUS VDD VDD sky130_fd_pr__pfet_01v8 L=0.15 W=1 nf=1 m=1
XM7 VOUT_MINUS VOUT_PLUS VDD VDD sky130_fd_pr__pfet_01v8 L=0.15 W=1 nf=1 m=1
XM8 VOUT_PLUS CLK VDD VDD sky130_fd_pr__pfet_01v8 L=0.15 W=10 nf=1 m=1
XM9 net2 CLK VDD VDD sky130_fd_pr__pfet_01v8 L=0.15 W=10 nf=1 m=1
XM10 VOUT_MINUS CLK VDD VDD sky130_fd_pr__pfet_01v8 L=0.15 W=10 nf=1 m=1
XM11 net3 CLK VDD VDD sky130_fd_pr__pfet_01v8 L=0.15 W=10 nf=1 m=1
.ends

* expanding   symbol:  post_amplifier.sym # of pins=5
** sym_path: /home/jrsharp/code/magma/xschem/tt/post_amplifier.sym
** sch_path: /home/jrsharp/code/magma/xschem/tt/post_amplifier.sch
.subckt post_amplifier VDD VLAT_PLUS VLAT_MINUS VOUT VSS
*.PININFO VLAT_PLUS:I VLAT_MINUS:I VDD:I VSS:I VOUT:O
XM1 net1 VLAT_PLUS net4 VSS sky130_fd_pr__nfet_01v8 L=0.15 W=1 nf=1 m=1
XM2 net3 VLAT_MINUS net4 VSS sky130_fd_pr__nfet_01v8 L=0.15 W=1 nf=1 m=1
XM3 net4 net1 VSS VSS sky130_fd_pr__nfet_01v8 L=0.15 W=1 nf=1 m=1
XM4 net1 VLAT_PLUS net2 VDD sky130_fd_pr__pfet_01v8 L=0.15 W=1 nf=1 m=1
XM5 net3 VLAT_MINUS net2 VDD sky130_fd_pr__pfet_01v8 L=0.15 W=1 nf=1 m=1
XM6 net2 net1 VDD VDD sky130_fd_pr__pfet_01v8 L=0.15 W=1 nf=1 m=1
XM7 VOUT net3 VSS VSS sky130_fd_pr__nfet_01v8 L=0.15 W=1 nf=1 m=1
XM8 VOUT net3 VDD VDD sky130_fd_pr__pfet_01v8 L=0.15 W=1 nf=1 m=1
.ends

.GLOBAL VSS
.end
