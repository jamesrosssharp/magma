* NGSPICE file created from high_speed_comp_top_routed.ext - technology: sky130A

.subckt high_speed_comp_top_routed VINP VINN VDD VSS CLK COMP_OUT
X0 a_504_4961# a_231_4595# a_419_4595# VDD.t2 sky130_fd_pr__pfet_01v8_hvt ad=0.06825 pd=0.745 as=0.05775 ps=0.695 w=0.42 l=0.15
X1 VDD.t26 a_672_4707# a_599_4961# VDD.t25 sky130_fd_pr__pfet_01v8_hvt ad=0.17887 pd=1.26 as=0.07665 ps=0.785 w=0.42 l=0.15
X2 a_929_2214# a_881_2436# VSS.t7 VSS.t6 sky130_fd_pr__nfet_01v8 ad=0.29 pd=2.58 as=0.29 ps=2.58 w=1 l=0.15
X3 a_929_4961# a_65_4595.t4 a_672_4707# VDD.t27 sky130_fd_pr__pfet_01v8_hvt ad=0.0567 pd=0.69 as=0.1095 ps=1.075 w=0.42 l=0.15
X4 VDD.t14 a_1097_4863# a_1013_4961# VDD.t13 sky130_fd_pr__pfet_01v8_hvt ad=0.1113 pd=1.37 as=0.0882 ps=0.84 w=0.42 l=0.15
X5 a_929_4961# a_231_4595# a_672_4707# VSS.t3 sky130_fd_pr__special_nfet_01v8 ad=0.0684 pd=0.74 as=0.0989 ps=0.995 w=0.36 l=0.15
X6 x3.D a_1561_2214# VDD.t31 VDD.t30 sky130_fd_pr__pfet_01v8 ad=0.29 pd=2.58 as=0.29 ps=2.58 w=1 l=0.15
X7 x2.VLAT_PLUS x4.Y.t17 VDD.t11 VDD.t10 sky130_fd_pr__pfet_01v8 ad=0.825 pd=5.33 as=1.55 ps=10.62 w=5 l=0.15
X8 a_231_4595# a_65_4595.t5 VSS.t21 VSS.t20 sky130_fd_pr__nfet_01v8 ad=0.1092 pd=1.36 as=0.0567 ps=0.69 w=0.42 l=0.15
X9 a_1561_2214# x2.VLAT_MINUS a_929_2214# VSS.t28 sky130_fd_pr__nfet_01v8 ad=0.29 pd=2.58 as=0.29 ps=2.58 w=1 l=0.15
X10 COMP_OUT a_1097_4863# VDD.t16 VDD.t15 sky130_fd_pr__pfet_01v8_hvt ad=0.135 pd=1.27 as=0.135 ps=1.27 w=1 l=0.15
X11 x4.Y.t4 CLK VDD.t47 VDD.t46 sky130_fd_pr__pfet_01v8_hvt ad=0.14 pd=1.28 as=0.305 ps=2.61 w=1 l=0.15
X12 VDD.t50 CLK x4.Y.t7 VDD.t49 sky130_fd_pr__pfet_01v8_hvt ad=0.14 pd=1.28 as=0.14 ps=1.28 w=1 l=0.15
X13 COMP_OUT a_1097_4863# VSS.t15 VSS.t14 sky130_fd_pr__nfet_01v8 ad=0.08775 pd=0.92 as=0.08775 ps=0.92 w=0.65 l=0.15
X14 VDD.t38 CLK a_65_4595.t1 VDD.t48 sky130_fd_pr__pfet_01v8_hvt ad=0.0864 pd=0.91 as=0.1664 ps=1.8 w=0.64 l=0.15
X15 x4.Y.t8 CLK VDD.t50 VDD.t54 sky130_fd_pr__pfet_01v8_hvt ad=0.14 pd=1.28 as=0.14 ps=1.28 w=1 l=0.15
X16 VSS.t35 VDD.t58 VSS.t34 VSS.t33 sky130_fd_pr__nfet_01v8 ad=0.143 pd=1.62 as=0 ps=0 w=0.55 l=0.59
X17 x2.VLAT_MINUS x4.Y.t15 VDD.t24 VDD.t23 sky130_fd_pr__pfet_01v8 ad=0.825 pd=5.33 as=1.55 ps=10.62 w=5 l=0.15
X18 VDD.t5 x4.Y.t14 x2.VLAT_MINUS VDD.t4 sky130_fd_pr__pfet_01v8 ad=1.55 pd=10.62 as=0.825 ps=5.33 w=5 l=0.15
X19 VDD.t52 CLK x4.Y.t5 VDD.t51 sky130_fd_pr__pfet_01v8_hvt ad=0.14 pd=1.28 as=0.14 ps=1.28 w=1 l=0.15
X20 a_932_2929# a_881_2436# VDD.t7 VDD.t6 sky130_fd_pr__pfet_01v8 ad=0.29 pd=2.58 as=0.29 ps=2.58 w=1 l=0.15
X21 a_1570_n470# x4.Y.t13 VDD.t5 VDD.t19 sky130_fd_pr__pfet_01v8 ad=0.825 pd=5.33 as=1.55 ps=10.62 w=5 l=0.15
X22 VDD.t16 a_929_4961# a_1097_4863# VDD.t36 sky130_fd_pr__pfet_01v8_hvt ad=0.135 pd=1.27 as=0.27 ps=2.54 w=1 l=0.15
X23 VDD.t40 x4.Y.t12 a_1570_n470# VDD.t39 sky130_fd_pr__pfet_01v8 ad=1.55 pd=10.62 as=0.825 ps=5.33 w=5 l=0.15
X24 VDD.t56 CLK x4.Y.t9 VDD.t55 sky130_fd_pr__pfet_01v8_hvt ad=0.345 pd=2.69 as=0.14 ps=1.28 w=1 l=0.15
X25 VSS.t15 a_929_4961# a_1097_4863# VSS.t31 sky130_fd_pr__nfet_01v8 ad=0.08775 pd=0.92 as=0.169 ps=1.82 w=0.65 l=0.15
X26 VSS.t38 VDD.t57 VSS.t37 VSS.t36 sky130_fd_pr__nfet_01v8 ad=0.143 pd=1.62 as=0 ps=0 w=0.55 l=0.59
X27 a_504_4961# a_65_4595.t3 a_419_4595# VSS.t4 sky130_fd_pr__special_nfet_01v8 ad=0.0621 pd=0.705 as=0.0813 ps=0.83 w=0.36 l=0.15
X28 VSS.t19 a_672_4707# a_630_4595# VSS.t18 sky130_fd_pr__nfet_01v8 ad=0.12095 pd=1.085 as=0.0696 ps=0.765 w=0.42 l=0.15
X29 x4.Y.t6 CLK VDD.t52 VDD.t53 sky130_fd_pr__pfet_01v8_hvt ad=0.14 pd=1.28 as=0.14 ps=1.28 w=1 l=0.15
X30 a_1561_2214# x2.VLAT_MINUS a_932_2929# VDD.t32 sky130_fd_pr__pfet_01v8 ad=0.29 pd=2.58 as=0.29 ps=2.58 w=1 l=0.15
X31 VSS.t11 x4.Y.t11 a_624_n1752# VSS.t30 sky130_fd_pr__nfet_01v8_lvt ad=0.725 pd=5.29 as=1.45 ps=10.58 w=5 l=1
X32 a_419_4595# x3.D VSS.t1 VSS.t0 sky130_fd_pr__nfet_01v8 ad=0.0813 pd=0.83 as=0.1092 ps=1.36 w=0.42 l=0.15
X33 a_630_4595# a_231_4595# a_504_4961# VSS.t2 sky130_fd_pr__special_nfet_01v8 ad=0.0696 pd=0.765 as=0.0621 ps=0.705 w=0.36 l=0.15
X34 a_929_2214# x2.VLAT_PLUS a_881_2436# VSS.t22 sky130_fd_pr__nfet_01v8 ad=0.29 pd=2.58 as=0.29 ps=2.58 w=1 l=0.15
X35 x2.VLAT_PLUS x2.VLAT_MINUS VDD.t34 VDD.t33 sky130_fd_pr__pfet_01v8 ad=0.29 pd=2.58 as=0.29 ps=2.58 w=1 l=0.15
X36 VDD.t22 VSS.t48 VDD.t21 VDD.t20 sky130_fd_pr__pfet_01v8_hvt ad=0.2262 pd=2.26 as=0 ps=0 w=0.87 l=0.59
X37 a_624_n1752# VINN a_1570_n470# VSS.t24 sky130_fd_pr__nfet_01v8_lvt ad=0.725 pd=5.29 as=1.45 ps=10.58 w=5 l=1
X38 VSS.t21 CLK a_65_4595.t0 VSS.t41 sky130_fd_pr__nfet_01v8 ad=0.0567 pd=0.69 as=0.1092 ps=1.36 w=0.42 l=0.15
X39 VDD.t18 a_1097_4863# COMP_OUT VDD.t17 sky130_fd_pr__pfet_01v8_hvt ad=0.26 pd=2.52 as=0.135 ps=1.27 w=1 l=0.15
X40 VSS.t17 a_1097_4863# COMP_OUT VSS.t16 sky130_fd_pr__nfet_01v8 ad=0.169 pd=1.82 as=0.08775 ps=0.92 w=0.65 l=0.15
X41 a_366_n1752# x4.Y.t19 VDD.t9 VDD.t8 sky130_fd_pr__pfet_01v8 ad=0.825 pd=5.33 as=1.55 ps=10.62 w=5 l=0.15
X42 x2.VLAT_PLUS x2.VLAT_MINUS a_366_n1752# VSS.t29 sky130_fd_pr__nfet_01v8 ad=0.29 pd=2.58 as=0.29 ps=2.58 w=1 l=0.15
X43 a_672_4707# a_504_4961# VSS.t19 VSS.t32 sky130_fd_pr__nfet_01v8 ad=0.0989 pd=0.995 as=0.12095 ps=1.085 w=0.64 l=0.15
X44 a_1055_4595# a_65_4595.t2 a_929_4961# VSS.t5 sky130_fd_pr__special_nfet_01v8 ad=0.066 pd=0.745 as=0.0684 ps=0.74 w=0.36 l=0.15
X45 VSS.t13 a_1097_4863# a_1055_4595# VSS.t12 sky130_fd_pr__nfet_01v8 ad=0.1092 pd=1.36 as=0.066 ps=0.745 w=0.42 l=0.15
X46 x3.D a_1561_2214# VSS.t27 VSS.t26 sky130_fd_pr__nfet_01v8 ad=0.29 pd=2.58 as=0.29 ps=2.58 w=1 l=0.15
X47 VDD.t11 x4.Y.t18 a_366_n1752# VDD.t12 sky130_fd_pr__pfet_01v8 ad=1.55 pd=10.62 as=0.825 ps=5.33 w=5 l=0.15
X48 VDD.t44 VSS.t47 VDD.t43 VDD.t42 sky130_fd_pr__pfet_01v8_hvt ad=0.2262 pd=2.26 as=0 ps=0 w=0.87 l=0.59
X49 a_1570_n470# VINN a_624_n1752# VSS.t25 sky130_fd_pr__nfet_01v8_lvt ad=1.45 pd=10.58 as=0.725 ps=5.29 w=5 l=1
X50 a_419_4595# x3.D VDD.t1 VDD.t0 sky130_fd_pr__pfet_01v8_hvt ad=0.05775 pd=0.695 as=0.1092 ps=1.36 w=0.42 l=0.15
X51 a_1013_4961# a_231_4595# a_929_4961# VDD.t3 sky130_fd_pr__pfet_01v8_hvt ad=0.0882 pd=0.84 as=0.0567 ps=0.69 w=0.42 l=0.15
X52 a_599_4961# a_65_4595.t6 a_504_4961# VDD.t35 sky130_fd_pr__pfet_01v8_hvt ad=0.07665 pd=0.785 as=0.06825 ps=0.745 w=0.42 l=0.15
X53 a_932_2929# x2.VLAT_PLUS a_881_2436# VDD.t28 sky130_fd_pr__pfet_01v8 ad=0.29 pd=2.58 as=0.29 ps=2.58 w=1 l=0.15
X54 a_624_n1752# x4.Y.t10 VSS.t11 VSS.t10 sky130_fd_pr__nfet_01v8_lvt ad=1.45 pd=10.58 as=0.725 ps=5.29 w=5 l=1
X55 x4.Y.t2 CLK VSS.t43 VSS.t44 sky130_fd_pr__nfet_01v8 ad=0.0588 pd=0.7 as=0.0588 ps=0.7 w=0.42 l=0.15
X56 VDD.t24 x2.VLAT_PLUS x2.VLAT_MINUS VDD.t29 sky130_fd_pr__pfet_01v8 ad=0.29 pd=2.58 as=0.29 ps=2.58 w=1 l=0.15
X57 a_672_4707# a_504_4961# VDD.t26 VDD.t45 sky130_fd_pr__pfet_01v8_hvt ad=0.1095 pd=1.075 as=0.17887 ps=1.26 w=0.75 l=0.15
X58 VSS.t46 CLK x4.Y.t3 VSS.t45 sky130_fd_pr__nfet_01v8 ad=0.1659 pd=1.63 as=0.0588 ps=0.7 w=0.42 l=0.15
X59 a_1570_n470# x2.VLAT_PLUS x2.VLAT_MINUS VSS.t23 sky130_fd_pr__nfet_01v8 ad=0.29 pd=2.58 as=0.29 ps=2.58 w=1 l=0.15
X60 a_231_4595# a_65_4595.t7 VDD.t38 VDD.t37 sky130_fd_pr__pfet_01v8_hvt ad=0.1664 pd=1.8 as=0.0864 ps=0.91 w=0.64 l=0.15
X61 x4.Y.t0 CLK VSS.t40 VSS.t39 sky130_fd_pr__nfet_01v8 ad=0.0588 pd=0.7 as=0.1386 ps=1.5 w=0.42 l=0.15
X62 VDD.t34 x4.Y.t16 x2.VLAT_PLUS VDD.t41 sky130_fd_pr__pfet_01v8 ad=1.55 pd=10.62 as=0.825 ps=5.33 w=5 l=0.15
X63 a_366_n1752# VINP a_624_n1752# VSS.t9 sky130_fd_pr__nfet_01v8_lvt ad=1.45 pd=10.58 as=0.725 ps=5.29 w=5 l=1
X64 a_624_n1752# VINP a_366_n1752# VSS.t8 sky130_fd_pr__nfet_01v8_lvt ad=0.725 pd=5.29 as=1.45 ps=10.58 w=5 l=1
X65 VSS.t43 CLK x4.Y.t1 VSS.t42 sky130_fd_pr__nfet_01v8 ad=0.0588 pd=0.7 as=0.0588 ps=0.7 w=0.42 l=0.15
R0 VDD.n142 VDD.n77 3031.76
R1 VDD.n142 VDD.n76 3031.76
R2 VDD.n133 VDD.n83 3031.76
R3 VDD.n104 VDD.n101 3031.76
R4 VDD.n109 VDD.n101 3031.76
R5 VDD.n114 VDD.n86 3031.76
R6 VDD.n139 VDD.n79 2290.59
R7 VDD.n139 VDD.n78 2290.59
R8 VDD.n106 VDD.n97 2290.59
R9 VDD.n106 VDD.n98 2290.59
R10 VDD.n87 VDD.n82 1510.59
R11 VDD.n94 VDD.n89 1510.59
R12 VDD.n69 VDD.n30 1312.94
R13 VDD.n54 VDD.n47 1312.94
R14 VDD.n135 VDD.n82 1238.82
R15 VDD.n116 VDD.n94 1238.82
R16 VDD.n19 VDD.t42 761.744
R17 VDD.n95 VDD.n92 755.294
R18 VDD.n92 VDD.n90 755.294
R19 VDD.n33 VDD.n32 755.294
R20 VDD.n32 VDD.n29 755.294
R21 VDD.n44 VDD.n43 755.294
R22 VDD.n44 VDD.n38 755.294
R23 VDD.n37 VDD.n35 755.294
R24 VDD.n60 VDD.n37 755.294
R25 VDD.n79 VDD.n77 741.178
R26 VDD.n135 VDD.n79 741.178
R27 VDD.n78 VDD.n76 741.178
R28 VDD.n133 VDD.n78 741.178
R29 VDD.n116 VDD.n97 741.178
R30 VDD.n104 VDD.n97 741.178
R31 VDD.n114 VDD.n98 741.178
R32 VDD.n109 VDD.n98 741.178
R33 VDD.t17 VDD.t20 739.875
R34 VDD.t42 VDD.t55 736.917
R35 VDD.t13 VDD.t36 621.495
R36 VDD.n88 VDD.n87 557.648
R37 VDD.n90 VDD.n88 557.648
R38 VDD.n128 VDD.n90 557.648
R39 VDD.n128 VDD.n89 557.648
R40 VDD.n93 VDD.n82 557.648
R41 VDD.n95 VDD.n93 557.648
R42 VDD.n123 VDD.n95 557.648
R43 VDD.n123 VDD.n94 557.648
R44 VDD.n67 VDD.n33 557.648
R45 VDD.n62 VDD.n33 557.648
R46 VDD.n62 VDD.n35 557.648
R47 VDD.n58 VDD.n35 557.648
R48 VDD.n58 VDD.n43 557.648
R49 VDD.n54 VDD.n43 557.648
R50 VDD.n69 VDD.n29 557.648
R51 VDD.n61 VDD.n29 557.648
R52 VDD.n61 VDD.n60 557.648
R53 VDD.n60 VDD.n59 557.648
R54 VDD.n59 VDD.n38 557.648
R55 VDD.n52 VDD.n38 557.648
R56 VDD.t37 VDD.t0 556.386
R57 VDD.t20 VDD.n24 544.548
R58 VDD.n17 VDD.n16 528.84
R59 VDD.n118 VDD.n17 528.84
R60 VDD.n24 VDD.t46 440.966
R61 VDD.t25 VDD.t45 390.654
R62 VDD.t29 VDD.n124 352.187
R63 VDD.n127 VDD.t33 352.187
R64 VDD.t3 VDD.t13 337.384
R65 VDD.n103 VDD.n102 323.526
R66 VDD.n143 VDD.n75 323.389
R67 VDD.t35 VDD.t25 304.829
R68 VDD.t2 VDD.t35 281.154
R69 VDD.t45 VDD.t27 281.154
R70 VDD.t6 VDD.n31 264.262
R71 VDD.t28 VDD.n31 264.262
R72 VDD.t28 VDD.n36 264.262
R73 VDD.t32 VDD.n36 264.262
R74 VDD.t32 VDD.n42 264.262
R75 VDD.t30 VDD.n42 264.262
R76 VDD.t51 VDD.t46 254.518
R77 VDD.t53 VDD.t51 254.518
R78 VDD.t49 VDD.t53 254.518
R79 VDD.t54 VDD.t49 254.518
R80 VDD.t55 VDD.t54 254.518
R81 VDD.t0 VDD.t2 251.559
R82 VDD.n102 VDD.n100 251.405
R83 VDD.n144 VDD.n143 250.345
R84 VDD.t48 VDD.t37 248.599
R85 VDD.t27 VDD.t3 248.599
R86 VDD.t36 VDD.t15 248.599
R87 VDD.t15 VDD.t17 248.599
R88 VDD.n138 VDD.n137 244.329
R89 VDD.n105 VDD.n96 244.329
R90 VDD.n138 VDD.n81 242.825
R91 VDD.n105 VDD.n99 242.825
R92 VDD.n68 VDD.n30 237.584
R93 VDD.n53 VDD.n47 237.584
R94 VDD.n24 VDD.n23 213.119
R95 VDD.n55 VDD.n46 139.976
R96 VDD.n118 VDD.n117 132.142
R97 VDD.n136 VDD.n16 132.142
R98 VDD.n66 VDD.n65 121.138
R99 VDD.n142 VDD.t8 117.906
R100 VDD.t39 VDD.n101 117.906
R101 VDD.t12 VDD.n140 107.025
R102 VDD.n140 VDD.t10 107.025
R103 VDD.n125 VDD.t41 107.025
R104 VDD.t23 VDD.n91 107.025
R105 VDD.n107 VDD.t4 107.025
R106 VDD.t19 VDD.n107 107.025
R107 VDD.n124 VDD.n93 92.5005
R108 VDD.n120 VDD.n93 92.5005
R109 VDD.n124 VDD.n123 92.5005
R110 VDD.n123 VDD.n122 92.5005
R111 VDD.n128 VDD.n127 92.5005
R112 VDD.n17 VDD.n128 92.5005
R113 VDD.n127 VDD.n88 92.5005
R114 VDD.n17 VDD.n88 92.5005
R115 VDD.n69 VDD.t6 92.5005
R116 VDD.n70 VDD.n69 92.5005
R117 VDD.t28 VDD.n61 92.5005
R118 VDD.n61 VDD.n26 92.5005
R119 VDD.n59 VDD.t32 92.5005
R120 VDD.n59 VDD.n41 92.5005
R121 VDD.n52 VDD.n51 92.5005
R122 VDD.n54 VDD.t30 92.5005
R123 VDD.n55 VDD.n54 92.5005
R124 VDD.t32 VDD.n58 92.5005
R125 VDD.n58 VDD.n57 92.5005
R126 VDD.n62 VDD.t28 92.5005
R127 VDD.n63 VDD.n62 92.5005
R128 VDD.n67 VDD.n66 92.5005
R129 VDD.n6 VDD.n46 83.2475
R130 VDD.n121 VDD.n119 80.5652
R131 VDD.n119 VDD.n17 80.5652
R132 VDD.n39 VDD.n34 80.5652
R133 VDD.n40 VDD.n39 80.5652
R134 VDD.n64 VDD.n27 80.5652
R135 VDD.n72 VDD.n27 80.5652
R136 VDD.n117 VDD.n96 79.0593
R137 VDD.n103 VDD.n96 79.0593
R138 VDD.n137 VDD.n75 79.0593
R139 VDD.n137 VDD.n136 79.0593
R140 VDD.n68 VDD.n67 70.7763
R141 VDD.n53 VDD.n52 70.7763
R142 VDD.n126 VDD.t29 65.0195
R143 VDD.t33 VDD.n126 65.0195
R144 VDD.n56 VDD.n45 61.6559
R145 VDD.n120 VDD.n16 59.4829
R146 VDD.n121 VDD.n120 59.4829
R147 VDD.n122 VDD.n121 59.4829
R148 VDD.n122 VDD.n118 59.4829
R149 VDD.n66 VDD.n64 59.4829
R150 VDD.n64 VDD.n63 59.4829
R151 VDD.n63 VDD.n34 59.4829
R152 VDD.n57 VDD.n34 59.4829
R153 VDD.n57 VDD.n56 59.4829
R154 VDD.n56 VDD.n55 59.4829
R155 VDD.n109 VDD.n108 46.2505
R156 VDD.n110 VDD.n109 46.2505
R157 VDD.n115 VDD.n114 46.2505
R158 VDD.n114 VDD.n113 46.2505
R159 VDD.n116 VDD.n115 46.2505
R160 VDD.n117 VDD.n116 46.2505
R161 VDD.n108 VDD.n104 46.2505
R162 VDD.n104 VDD.n103 46.2505
R163 VDD.n126 VDD.n92 46.2505
R164 VDD.n119 VDD.n92 46.2505
R165 VDD.n135 VDD.n134 46.2505
R166 VDD.n136 VDD.n135 46.2505
R167 VDD.n141 VDD.n77 46.2505
R168 VDD.n77 VDD.n75 46.2505
R169 VDD.n141 VDD.n76 46.2505
R170 VDD.n76 VDD.n74 46.2505
R171 VDD.n134 VDD.n133 46.2505
R172 VDD.n133 VDD.n132 46.2505
R173 VDD.n47 VDD.n46 46.2505
R174 VDD.n65 VDD.n30 46.2505
R175 VDD.n32 VDD.n31 46.2505
R176 VDD.n32 VDD.n27 46.2505
R177 VDD.n44 VDD.n42 46.2505
R178 VDD.n45 VDD.n44 46.2505
R179 VDD.n37 VDD.n36 46.2505
R180 VDD.n39 VDD.n37 46.2505
R181 VDD.n87 VDD.n83 42.3534
R182 VDD.n89 VDD.n86 42.3534
R183 VDD.n126 VDD.n125 35.0144
R184 VDD.n126 VDD.n91 35.0144
R185 VDD.n1 VDD.t26 23.7599
R186 VDD.t8 VDD.n141 31.7112
R187 VDD.n141 VDD.t12 31.7112
R188 VDD.n134 VDD.t10 31.7112
R189 VDD.n134 VDD.t41 31.7112
R190 VDD.n115 VDD.t23 31.7112
R191 VDD.n115 VDD.t4 31.7112
R192 VDD.n108 VDD.t19 31.7112
R193 VDD.n108 VDD.t39 31.7112
R194 VDD.t16 VDD.n9 37.4011
R195 VDD.n15 VDD.t50 32.9936
R196 VDD.t1 VDD.n2 35.054
R197 VDD.n13 VDD.t52 5.38743
R198 VDD.n10 VDD.t18 31.6517
R199 VDD.t52 VDD.n14 29.036
R200 VDD.t48 VDD.n7 631.112
R201 VDD.n8 VDD.t38 27.9878
R202 VDD.t1 VDD.n8 5.02305
R203 VDD.n14 VDD.t50 4.94188
R204 VDD.n13 VDD.t47 24.9639
R205 VDD.n2 VDD.t26 26.0187
R206 VDD.t30 VDD.n53 16.7394
R207 VDD.t6 VDD.n68 16.7394
R208 VDD.n15 VDD.t56 4.38186
R209 VDD.n1 VDD.t14 22.6305
R210 VDD.t7 VDD.n28 14.4208
R211 VDD.n49 VDD.t31 14.4208
R212 VDD.t56 VDD.n21 14.2735
R213 VDD.n23 VDD.t21 14.2735
R214 VDD.n113 VDD.n99 13.8562
R215 VDD.n132 VDD.n81 13.8562
R216 VDD.n130 VDD.n129 13.5861
R217 VDD.n111 VDD.n110 13.3283
R218 VDD.n80 VDD.n74 13.2624
R219 VDD.n12 VDD.t47 3.79208
R220 VDD.n102 VDD.n101 11.0403
R221 VDD.n125 VDD.n83 10.8829
R222 VDD.n129 VDD.n83 10.8829
R223 VDD.n91 VDD.n86 10.8829
R224 VDD.n129 VDD.n86 10.8829
R225 VDD.n143 VDD.n142 10.8829
R226 VDD.n140 VDD.n139 10.8829
R227 VDD.n139 VDD.n138 10.8829
R228 VDD.n107 VDD.n106 10.8829
R229 VDD.n106 VDD.n105 10.8829
R230 VDD.n28 VDD.n5 10.7856
R231 VDD.n4 VDD.n6 9.5505
R232 VDD.n131 VDD.t34 9.3005
R233 VDD.n80 VDD.t11 9.3005
R234 VDD.t9 VDD.n144 9.3005
R235 VDD.n100 VDD.t40 9.3005
R236 VDD.t5 VDD.n111 9.3005
R237 VDD.n112 VDD.t24 9.3005
R238 VDD.n71 VDD.n5 9.3005
R239 VDD.n5 VDD.n73 9.3005
R240 VDD.n5 VDD.n25 9.3005
R241 VDD.n48 VDD.n4 9.3005
R242 VDD.n50 VDD.n4 9.3005
R243 VDD.t38 VDD.n7 6.51996
R244 VDD.n0 VDD.n8 2.13997
R245 VDD.n1 VDD.n0 0.0538366
R246 VDD.n9 VDD.t14 5.77756
R247 VDD.n9 VDD.n0 1.76272
R248 VDD.n0 VDD.n10 1.62567
R249 VDD.n11 VDD.n0 1.97608
R250 VDD.n3 VDD.n22 9.3005
R251 VDD.n3 VDD.t21 9.3005
R252 VDD.n23 VDD.n12 3.79208
R253 VDD.n3 VDD.n12 2.75546
R254 VDD.n13 VDD.n3 1.95779
R255 VDD.n3 VDD.n14 2.18056
R256 VDD.n15 VDD.n3 2.46057
R257 VDD.n21 VDD.n3 9.3005
R258 VDD.n3 VDD.n20 9.3005
R259 VDD.n11 VDD.t18 14.3861
R260 VDD.n112 VDD.n84 7.45617
R261 VDD.n131 VDD.n84 7.39019
R262 VDD.n49 VDD.n48 6.77477
R263 VDD.n110 VDD.n100 6.33452
R264 VDD.n144 VDD.n74 6.33452
R265 VDD.n41 VDD.n40 5.91395
R266 VDD.n26 VDD.n25 5.53968
R267 VDD.n113 VDD.n112 5.27885
R268 VDD.n132 VDD.n131 5.21287
R269 VDD.n85 VDD.n130 4.53781
R270 VDD.n20 VDD.t44 4.36875
R271 VDD.n22 VDD.t22 4.36875
R272 VDD.n51 VDD.n6 4.34202
R273 VDD.t43 VDD.n19 4.32903
R274 VDD.n73 VDD.n72 3.96775
R275 VDD.n70 VDD.n28 3.85547
R276 VDD.n72 VDD.n71 3.51863
R277 VDD.n20 VDD.t57 3.50526
R278 VDD.n22 VDD.t58 3.50526
R279 VDD.n51 VDD.n50 3.14436
R280 VDD.n10 VDD.t16 9.06342
R281 VDD.n65 VDD.t7 2.91696
R282 VDD.t31 VDD.n45 2.91696
R283 VDD.n3 VDD.n19 2.77604
R284 VDD.n71 VDD.n70 2.39582
R285 VDD.n73 VDD.n26 1.9467
R286 VDD.n18 VDD.t9 1.90925
R287 VDD.n18 VDD.n5 1.23862
R288 VDD.n48 VDD.n41 1.19816
R289 VDD.t58 VDD.t21 1.16875
R290 VDD.n0 VDD.n18 1.1136
R291 VDD.t57 VDD.t43 0.863992
R292 VDD.n50 VDD.n49 0.711611
R293 VDD.n129 VDD.n17 0.671159
R294 VDD.n130 VDD.n84 0.632835
R295 VDD.n81 VDD.n80 0.594314
R296 VDD.t34 VDD.n85 0.555508
R297 VDD.t24 VDD.n85 0.555508
R298 VDD.n111 VDD.n99 0.528335
R299 VDD.t5 VDD.t40 0.466125
R300 VDD.t34 VDD.t11 0.466125
R301 VDD.t24 VDD.t5 0.466125
R302 VDD.t9 VDD.t11 0.464563
R303 VDD.n40 VDD.n25 0.374769
R304 VDD.n21 VDD.t44 0.305262
R305 VDD.t22 VDD.n11 5.6556
R306 VDD.n3 VDD.n0 1.67758
R307 VDD.n0 VDD.n7 1.45767
R308 VDD.n0 VDD.n2 1.01217
R309 VDD.n5 VDD.n4 1.0005
R310 VSS.n114 VSS.n19 31682
R311 VSS.n82 VSS.n19 6946.7
R312 VSS.n114 VSS.n113 6833.55
R313 VSS.n86 VSS.n81 5684.03
R314 VSS.n84 VSS.n81 5684.03
R315 VSS.n112 VSS.n56 5684.03
R316 VSS.n112 VSS.n57 5684.03
R317 VSS.n107 VSS.n62 3425.61
R318 VSS.n107 VSS.n61 3425.61
R319 VSS.n90 VSS.n75 3333.03
R320 VSS.n90 VSS.n71 3333.03
R321 VSS.n125 VSS.n18 2126.44
R322 VSS.n125 VSS.n17 2126.44
R323 VSS.n54 VSS.n21 2126.44
R324 VSS.n54 VSS.n20 2126.44
R325 VSS.n93 VSS.n74 2126.44
R326 VSS.n94 VSS.n74 2126.44
R327 VSS.n104 VSS.n64 2126.44
R328 VSS.n104 VSS.n65 2126.44
R329 VSS.n61 VSS.n56 2056.91
R330 VSS.n96 VSS.n61 2056.91
R331 VSS.n70 VSS.n62 2056.91
R332 VSS.n62 VSS.n57 2056.91
R333 VSS.n96 VSS.n71 2039.53
R334 VSS.n75 VSS.n70 2039.53
R335 VSS.n86 VSS.n75 2039.53
R336 VSS.n84 VSS.n71 2039.53
R337 VSS.n99 VSS.n69 1272.06
R338 VSS.n99 VSS.n68 1272.06
R339 VSS.n30 VSS.n29 1210.97
R340 VSS.n29 VSS.n25 1210.97
R341 VSS.n33 VSS.n31 1210.97
R342 VSS.n33 VSS.n26 1210.97
R343 VSS.n39 VSS.n35 1210.97
R344 VSS.n39 VSS.n37 1210.97
R345 VSS.n123 VSS.n122 1205.01
R346 VSS.n119 VSS.n118 1198.25
R347 VSS.n35 VSS.n18 915.471
R348 VSS.n44 VSS.n35 915.471
R349 VSS.n44 VSS.n31 915.471
R350 VSS.n48 VSS.n31 915.471
R351 VSS.n48 VSS.n30 915.471
R352 VSS.n30 VSS.n21 915.471
R353 VSS.n37 VSS.n17 915.471
R354 VSS.n43 VSS.n37 915.471
R355 VSS.n43 VSS.n26 915.471
R356 VSS.n49 VSS.n26 915.471
R357 VSS.n49 VSS.n25 915.471
R358 VSS.n25 VSS.n20 915.471
R359 VSS.n68 VSS.n64 816.971
R360 VSS.n93 VSS.n68 816.971
R361 VSS.n94 VSS.n69 816.971
R362 VSS.n69 VSS.n65 816.971
R363 VSS.t33 VSS.t16 712.273
R364 VSS.t31 VSS.t12 542.821
R365 VSS.n124 VSS.t6 538.082
R366 VSS.n36 VSS.t6 538.082
R367 VSS.t22 VSS.n36 538.082
R368 VSS.t22 VSS.n28 538.082
R369 VSS.t28 VSS.n28 538.082
R370 VSS.t28 VSS.n27 538.082
R371 VSS.n27 VSS.t26 538.082
R372 VSS.n55 VSS.t26 538.082
R373 VSS.n118 VSS.t33 528.46
R374 VSS.n123 VSS.n19 457.901
R375 VSS.n118 VSS.n117 436.555
R376 VSS.t45 VSS.t36 434.553
R377 VSS.t8 VSS.n82 414.579
R378 VSS.n91 VSS.t9 414.579
R379 VSS.n106 VSS.t24 414.579
R380 VSS.n113 VSS.t25 414.579
R381 VSS.t18 VSS.t32 364.752
R382 VSS.t5 VSS.t3 304.44
R383 VSS.t29 VSS.n93 292.5
R384 VSS.n93 VSS.n66 292.5
R385 VSS.n64 VSS.t23 292.5
R386 VSS.n102 VSS.n64 292.5
R387 VSS.n65 VSS.t23 292.5
R388 VSS.n67 VSS.n65 292.5
R389 VSS.n94 VSS.t29 292.5
R390 VSS.n95 VSS.n94 292.5
R391 VSS.t6 VSS.n17 292.5
R392 VSS.n17 VSS.n16 292.5
R393 VSS.t22 VSS.n43 292.5
R394 VSS.n43 VSS.n42 292.5
R395 VSS.n49 VSS.t28 292.5
R396 VSS.n50 VSS.n49 292.5
R397 VSS.n20 VSS.t26 292.5
R398 VSS.n52 VSS.n20 292.5
R399 VSS.n21 VSS.t26 292.5
R400 VSS.n22 VSS.n21 292.5
R401 VSS.t28 VSS.n48 292.5
R402 VSS.n48 VSS.n47 292.5
R403 VSS.n44 VSS.t22 292.5
R404 VSS.n45 VSS.n44 292.5
R405 VSS.t6 VSS.n18 292.5
R406 VSS.n18 VSS.n15 292.5
R407 VSS.t3 VSS.t32 290.079
R408 VSS.n116 VSS.n114 276.298
R409 VSS.t12 VSS.t5 272.846
R410 VSS.t29 VSS.n92 269.562
R411 VSS.n105 VSS.t23 269.562
R412 VSS.n111 VSS.n58 249.637
R413 VSS.n87 VSS.n80 248.454
R414 VSS.t0 VSS.t20 243.869
R415 VSS.t14 VSS.t31 241.254
R416 VSS.t16 VSS.t14 241.254
R417 VSS.t36 VSS.n116 238.679
R418 VSS.n111 VSS.n110 237.898
R419 VSS.n83 VSS.n80 237.736
R420 VSS.n85 VSS.t8 220.085
R421 VSS.n85 VSS.t9 220.085
R422 VSS.n97 VSS.t30 220.085
R423 VSS.t24 VSS.n63 220.085
R424 VSS.n63 VSS.t25 220.085
R425 VSS.n98 VSS.t10 216.673
R426 VSS.n108 VSS.n60 216.534
R427 VSS.n109 VSS.n108 216.534
R428 VSS.n89 VSS.n88 210.681
R429 VSS.n89 VSS.n76 210.681
R430 VSS.n117 VSS.n55 190.713
R431 VSS.t41 VSS.n123 180.308
R432 VSS.n124 VSS.t18 170.28
R433 VSS.n105 VSS.n104 146.25
R434 VSS.n104 VSS.n103 146.25
R435 VSS.n92 VSS.n74 146.25
R436 VSS.n74 VSS.n73 146.25
R437 VSS.n99 VSS.n98 146.25
R438 VSS.n100 VSS.n99 146.25
R439 VSS.n55 VSS.n54 146.25
R440 VSS.n54 VSS.n53 146.25
R441 VSS.n125 VSS.n124 146.25
R442 VSS.n126 VSS.n125 146.25
R443 VSS.n39 VSS.n36 146.25
R444 VSS.n40 VSS.n39 146.25
R445 VSS.n33 VSS.n28 146.25
R446 VSS.n34 VSS.n33 146.25
R447 VSS.n29 VSS.n27 146.25
R448 VSS.n29 VSS.n23 146.25
R449 VSS.t4 VSS.t0 145.284
R450 VSS.n53 VSS.n52 138.183
R451 VSS.n73 VSS.n66 138.166
R452 VSS.n103 VSS.n102 138.166
R453 VSS.t2 VSS.t4 128.421
R454 VSS.t18 VSS.t2 118.043
R455 VSS.n126 VSS.n16 117.778
R456 VSS.t39 VSS.t42 111.558
R457 VSS.t42 VSS.t44 111.558
R458 VSS.t44 VSS.t45 111.558
R459 VSS.t20 VSS.t41 108.963
R460 VSS.n117 VSS.t39 107.665
R461 VSS.n95 VSS.n72 98.6537
R462 VSS.n67 VSS.n59 98.6537
R463 VSS.n92 VSS.n91 93.8353
R464 VSS.n106 VSS.n105 93.8353
R465 VSS.n53 VSS.n22 85.5375
R466 VSS.n101 VSS.n100 82.6519
R467 VSS.n46 VSS.n34 78.6829
R468 VSS.n34 VSS.n24 78.6829
R469 VSS.n40 VSS.n38 78.6829
R470 VSS.n41 VSS.n40 78.6829
R471 VSS.n100 VSS.n6 76.4348
R472 VSS.n85 VSS.n84 65.0005
R473 VSS.n84 VSS.n83 65.0005
R474 VSS.n97 VSS.n96 65.0005
R475 VSS.n96 VSS.n6 65.0005
R476 VSS.n63 VSS.n56 65.0005
R477 VSS.n110 VSS.n56 65.0005
R478 VSS.n63 VSS.n57 65.0005
R479 VSS.n58 VSS.n57 65.0005
R480 VSS.n97 VSS.n70 65.0005
R481 VSS.n78 VSS.n70 65.0005
R482 VSS.n86 VSS.n85 65.0005
R483 VSS.n87 VSS.n86 65.0005
R484 VSS.n41 VSS.n16 59.4829
R485 VSS.n42 VSS.n41 59.4829
R486 VSS.n42 VSS.n24 59.4829
R487 VSS.n50 VSS.n24 59.4829
R488 VSS.n51 VSS.n50 59.4829
R489 VSS.n52 VSS.n51 59.4829
R490 VSS.n51 VSS.n23 58.2963
R491 VSS.t10 VSS.t23 54.5953
R492 VSS.n102 VSS.n101 53.0829
R493 VSS.n101 VSS.n66 53.0829
R494 VSS.t29 VSS.t30 46.0649
R495 VSS.n113 VSS.n112 36.563
R496 VSS.n112 VSS.n111 36.563
R497 VSS.n82 VSS.n81 36.563
R498 VSS.n81 VSS.n80 36.563
R499 VSS.n91 VSS.n90 36.563
R500 VSS.n90 VSS.n89 36.563
R501 VSS.n107 VSS.n106 36.563
R502 VSS.n108 VSS.n107 36.563
R503 VSS.n5 VSS.n1 1.72683
R504 VSS.t19 VSS.n2 5.08327
R505 VSS.n7 VSS.t15 38.2073
R506 VSS.n8 VSS.t17 32.4046
R507 VSS.t40 VSS.n10 30.4369
R508 VSS.t43 VSS.n11 28.3642
R509 VSS.t21 VSS.n5 28.3575
R510 VSS.n2 VSS.t13 30.4329
R511 VSS.n12 VSS.t46 23.9
R512 VSS.n73 VSS.n72 18.0711
R513 VSS.n103 VSS.n59 18.0711
R514 VSS.n60 VSS.n58 18.0171
R515 VSS.n127 VSS.t7 17.926
R516 VSS.n88 VSS.n87 17.8722
R517 VSS.n6 VSS.n67 16.1529
R518 VSS.n120 VSS.n119 14.8179
R519 VSS.n116 VSS.n13 1202.37
R520 VSS.n32 VSS.t27 14.4208
R521 VSS.n3 VSS.t11 11.8786
R522 VSS.n3 VSS.n128 11.438
R523 VSS.n88 VSS.n79 11.0626
R524 VSS.n6 VSS.n95 16.0513
R525 VSS.n77 VSS.t11 9.55388
R526 VSS.n128 VSS.n14 9.5505
R527 VSS.n13 VSS.n0 2.58917
R528 VSS.n119 VSS.n10 5.21334
R529 VSS.n0 VSS.n10 2.04483
R530 VSS.n11 VSS.t40 5.02305
R531 VSS.n11 VSS.n0 2.13997
R532 VSS.t43 VSS.n12 5.45298
R533 VSS.n0 VSS.n12 1.92501
R534 VSS.n4 VSS.t46 6.9707
R535 VSS.n4 VSS.n0 0.405309
R536 VSS.n0 VSS.n115 9.3005
R537 VSS.n1 VSS.n120 9.3005
R538 VSS.n121 VSS.n1 9.3005
R539 VSS.n9 VSS.n1 1.95183
R540 VSS.n8 VSS.n1 1.62567
R541 VSS.n1 VSS.n7 1.73611
R542 VSS.n7 VSS.t13 5.83079
R543 VSS.t1 VSS.n5 4.26202
R544 VSS.n128 VSS.n127 9.3005
R545 VSS.n78 VSS.n77 9.22616
R546 VSS.n77 VSS.n60 8.79144
R547 VSS.n47 VSS.n32 8.38942
R548 VSS.n110 VSS.n109 8.3038
R549 VSS.n9 VSS.t17 13.6817
R550 VSS.n83 VSS.n76 8.23702
R551 VSS.n122 VSS.t21 6.49493
R552 VSS.n38 VSS.n15 6.22327
R553 VSS.n46 VSS.n45 6.22327
R554 VSS.n47 VSS.n46 6.22327
R555 VSS.n121 VSS.t34 5.98311
R556 VSS.n115 VSS.t37 5.98311
R557 VSS.n45 VSS.n14 5.1205
R558 VSS.t48 VSS.n121 4.8005
R559 VSS.n115 VSS.t47 4.8005
R560 VSS.n32 VSS.n22 4.05712
R561 VSS.n79 VSS.n78 3.58653
R562 VSS.n98 VSS.n97 3.41268
R563 VSS.n79 VSS.t11 3.11691
R564 VSS.t27 VSS.n23 2.51189
R565 VSS.t7 VSS.n126 2.51189
R566 VSS.t15 VSS.n8 8.31048
R567 VSS.t35 VSS.t48 1.18311
R568 VSS.t47 VSS.t38 1.18311
R569 VSS.n38 VSS.n14 1.10327
R570 VSS.n76 VSS.n72 0.890935
R571 VSS.n109 VSS.n59 0.824152
R572 VSS.n122 VSS.n1 0.658169
R573 VSS.n127 VSS.n15 0.551885
R574 VSS.n9 VSS.t35 5.81674
R575 VSS.n120 VSS.t34 0.417891
R576 VSS.t38 VSS.n4 7.27851
R577 VSS.n13 VSS.t37 4.54204
R578 VSS.n1 VSS.n0 1.67498
R579 VSS.n0 VSS.n3 1.37706
R580 VSS.n1 VSS.n2 1.22573
R581 x4.Y.n2 x4.Y.t15 1043.42
R582 x4.Y.n3 x4.Y.t16 1043.42
R583 x4.Y.n2 x4.Y.t13 1043.25
R584 x4.Y.n3 x4.Y.t18 1043.25
R585 x4.Y.n1 x4.Y.t12 1038.91
R586 x4.Y.n0 x4.Y.t19 1038.91
R587 x4.Y.n1 x4.Y.t14 1038.54
R588 x4.Y.n0 x4.Y.t17 1038.54
R589 x4.Y.n15 x4.Y.n10 312.226
R590 x4.Y.n14 x4.Y.n11 312.226
R591 x4.Y.n13 x4.Y.n12 311.849
R592 x4.Y.n5 x4.Y.t10 214.587
R593 x4.Y.n5 x4.Y.t11 214.587
R594 x4.Y.n17 x4.Y.n8 203.322
R595 x4.Y.n16 x4.Y.n9 202.97
R596 x4.Y.n16 x4.Y.n15 137.036
R597 x4.Y.n18 x4.Y.n17 51.9534
R598 x4.Y.n15 x4.Y.n14 45.5534
R599 x4.Y.n14 x4.Y.n13 45.177
R600 x4.Y.n17 x4.Y.n16 45.177
R601 x4.Y.n9 x4.Y.t0 40.0005
R602 x4.Y.n9 x4.Y.t1 40.0005
R603 x4.Y.n8 x4.Y.t2 40.0005
R604 x4.Y.n8 x4.Y.t3 40.0005
R605 x4.Y.n12 x4.Y.t8 27.5805
R606 x4.Y.n12 x4.Y.t9 27.5805
R607 x4.Y.n11 x4.Y.t6 27.5805
R608 x4.Y.n11 x4.Y.t7 27.5805
R609 x4.Y.n10 x4.Y.t4 27.5805
R610 x4.Y.n10 x4.Y.t5 27.5805
R611 x4.Y.n7 x4.Y 26.898
R612 x4.Y.n13 x4.Y 23.4672
R613 x4.Y x4.Y.n18 12.5872
R614 x4.Y x4.Y.n7 10.8805
R615 x4.Y x4.Y.n6 8.97312
R616 x4.Y.n6 x4.Y.n5 8.22323
R617 x4.Y.n6 x4.Y.n4 7.91176
R618 x4.Y.n1 x4.Y.n2 5.898
R619 x4.Y.n0 x4.Y.n3 5.898
R620 x4.Y x4.Y.n7 3.62717
R621 x4.Y.n18 x4.Y 1.9205
R622 x4.Y.n4 x4.Y.n0 1.19112
R623 x4.Y.n4 x4.Y.n1 1.17863
R624 a_65_4595.n2 a_65_4595.t2 443.44
R625 a_65_4595.t1 a_65_4595.n5 390.067
R626 a_65_4595.n3 a_65_4595.t3 345.305
R627 a_65_4595.n3 a_65_4595.t6 296.969
R628 a_65_4595.n1 a_65_4595.t0 287.998
R629 a_65_4595.n0 a_65_4595.t7 263.173
R630 a_65_4595.n2 a_65_4595.t4 254.389
R631 a_65_4595.n0 a_65_4595.t5 227.826
R632 a_65_4595.n4 a_65_4595.n2 193.59
R633 a_65_4595.n1 a_65_4595.n0 152
R634 a_65_4595.n5 a_65_4595.n1 35.3396
R635 a_65_4595.n4 a_65_4595.n3 12.4401
R636 a_65_4595.n5 a_65_4595.n4 11.0742
C0 a_1561_2214# x2.VLAT_MINUS 0.33021f
C1 a_1097_4863# COMP_OUT 0.19318f
C2 x4.Y a_1570_n470# 0.60943f
C3 x4.Y x2.VLAT_PLUS 1.60268f
C4 a_366_n1752# VINP 0.75123f
C5 a_366_n1752# x4.Y 0.71737f
C6 x2.VLAT_PLUS a_881_2436# 0.31507f
C7 VINN a_1570_n470# 0.75016f
C8 a_929_2214# x2.VLAT_PLUS 0.22271f
C9 a_1570_n470# a_624_n1752# 1.07677f
C10 a_231_4595# a_929_4961# 0.19718f
C11 a_366_n1752# a_624_n1752# 1.15167f
C12 a_1570_n470# x2.VLAT_MINUS 0.85021f
C13 x4.Y CLK 0.75325f
C14 x2.VLAT_PLUS x2.VLAT_MINUS 0.98954f
C15 a_1097_4863# a_929_4961# 0.31086f
C16 x3.D a_419_4595# 0.12351f
C17 x4.Y x3.D 0.86691f
C18 a_231_4595# a_672_4707# 0.12813f
C19 a_932_2929# a_881_2436# 0.3501f
C20 a_231_4595# a_419_4595# 0.1033f
C21 a_624_n1752# VINP 0.65494f
C22 x4.Y a_624_n1752# 0.74231f
C23 a_929_2214# a_881_2436# 0.34901f
C24 x4.Y x2.VLAT_MINUS 1.13471f
C25 VINN a_624_n1752# 0.65468f
C26 a_504_4961# a_672_4707# 0.23992f
C27 a_231_4595# x3.D 0.23058f
C28 CLK COMP_OUT 0.2043f
C29 x2.VLAT_MINUS a_624_n1752# 0.13604f
C30 a_366_n1752# x2.VLAT_PLUS 0.53984f
C31 a_1561_2214# a_932_2929# 0.17077f
C32 a_1561_2214# x3.D 0.21045f
C33 a_929_2214# a_1561_2214# 0.17079f
C34 COMP_OUT 0 0.70496f
C35 a_624_n1752# 0 5.27546f
C36 a_1570_n470# 0 3.24578f
C37 a_366_n1752# 0 3.16859f
C38 a_929_2214# 0 4.84864f
C39 a_881_2436# 0 1.86492f
C40 x4.Y 0 8.75706f
C41 a_1013_4961# 0 0.20106f
C42 a_599_4961# 0 0.17441f
C43 a_419_4595# 0 2.09449f
C44 a_672_4707# 0 0.2682f
C45 a_65_4595.n0 0 0.1518f
C46 a_65_4595.n1 0 0.24339f
C47 a_65_4595.n2 0 0.19709f
C48 a_65_4595.n3 0 0.35784f
C49 a_65_4595.n4 0 0.57665f
C50 a_65_4595.n5 0 0.22718f
C51 a_65_4595.t1 0 0.12125f
C52 x4.Y.n0 0 0.53061f
C53 x4.Y.n1 0 0.5289f
C54 x4.Y.n2 0 1.0245f
C55 x4.Y.n3 0 1.0245f
C56 x4.Y.n4 0 0.26779f
C57 x4.Y.n5 0 0.7234f
C58 x4.Y.n6 0 1.61779f
C59 x4.Y.n7 0 1.25837f
C60 x4.Y.t4 0 1.01692f
C61 VSS.t11 0 0.98228f
C62 VSS.t27 0 1.02488f
C63 VSS.t19 0 0.26106f
C64 VSS.t1 0 1.24438f
C65 VSS.t7 0 0.27803f
C66 VDD.n0 0 0.88477f
C67 VDD.n3 0 0.23982f
C68 VDD.n4 0 0.10667f
C69 VDD.n5 0 0.54653f
C70 VDD.n7 0 0.10728f
C71 VDD.n18 0 3.3609f
C72 VDD.t47 0 1.05663f
C73 VDD.t55 0 0.10502f
C74 VDD.t42 0 0.17012f
C75 VDD.n19 0 0.12379f
C76 VDD.t18 0 0.11332f
C77 VDD.t14 0 0.23173f
C78 VDD.t26 0 0.1908f
C79 VDD.t1 0 0.53982f
C80 VDD.t16 0 0.19165f
C81 VDD.n24 0 0.11393f
C82 VDD.t20 0 0.13606f
C83 VDD.t17 0 0.10471f
C84 VDD.t13 0 0.10158f
C85 VDD.t48 0 0.10712f
C86 VDD.n28 0 0.11395f
C87 VDD.n30 0 0.1503f
C88 VDD.n31 0 0.1753f
C89 VDD.n36 0 0.1753f
C90 VDD.n42 0 0.1753f
C91 VDD.n47 0 0.1503f
C92 VDD.t31 0 0.3506f
C93 VDD.t30 0 0.19711f
C94 VDD.t32 0 0.1753f
C95 VDD.t28 0 0.1753f
C96 VDD.t6 0 0.19711f
C97 VDD.t11 0 0.77651f
C98 VDD.t10 0 0.29493f
C99 VDD.t41 0 0.29493f
C100 VDD.n84 0 0.19073f
C101 VDD.t5 0 0.77907f
C102 VDD.n85 0 0.29697f
C103 VDD.t24 0 0.66221f
C104 VDD.n91 0 0.30195f
C105 VDD.t4 0 0.29493f
C106 VDD.t23 0 0.29493f
C107 VDD.t40 0 0.43874f
C108 VDD.n101 0 0.3995f
C109 VDD.t39 0 0.32967f
C110 VDD.n107 0 0.45504f
C111 VDD.t19 0 0.29493f
C112 VDD.n108 0 0.13483f
C113 VDD.n115 0 0.13483f
C114 VDD.n124 0 0.15463f
C115 VDD.t29 0 0.11867f
C116 VDD.n125 0 0.30195f
C117 VDD.n126 0 0.18586f
C118 VDD.t33 0 0.11867f
C119 VDD.n127 0 0.15463f
C120 VDD.n129 0 0.48148f
C121 VDD.n130 0 0.48409f
C122 VDD.t34 0 0.65686f
C123 VDD.n134 0 0.13483f
C124 VDD.n140 0 0.45504f
C125 VDD.t12 0 0.29493f
C126 VDD.n141 0 0.13483f
C127 VDD.t8 0 0.32967f
C128 VDD.n142 0 0.39925f
C129 VDD.t9 0 1.01441f
.ends
