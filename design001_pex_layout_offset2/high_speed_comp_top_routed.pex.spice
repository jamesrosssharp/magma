* NGSPICE file created from high_speed_comp_top_routed.ext - technology: sky130A

.subckt high_speed_comp_top_routed VINP VINN VDD VSS CLK COMP_OUT
X0 a_504_4961# a_231_4595# a_419_4595# VDD.t13 sky130_fd_pr__pfet_01v8_hvt ad=0.06825 pd=0.745 as=0.05775 ps=0.695 w=0.42 l=0.15
X1 VDD.t16 a_672_4707# a_599_4961# VDD.t15 sky130_fd_pr__pfet_01v8_hvt ad=0.17887 pd=1.26 as=0.07665 ps=0.785 w=0.42 l=0.15
X2 a_1570_n570# x4.Y.t13 VDD.t39 VDD.t56 sky130_fd_pr__pfet_01v8 ad=0.825 pd=5.33 as=1.55 ps=10.62 w=5 l=0.15
X3 a_929_2214# a_881_2436# VSS.t1 VSS.t0 sky130_fd_pr__nfet_01v8 ad=0.29 pd=2.58 as=0.29 ps=2.58 w=1 l=0.15
X4 a_929_4961# a_65_4595# a_672_4707# VDD.t10 sky130_fd_pr__pfet_01v8_hvt ad=0.0567 pd=0.69 as=0.1095 ps=1.075 w=0.42 l=0.15
X5 VDD.t19 a_1097_4863# a_1013_4961# VDD.t18 sky130_fd_pr__pfet_01v8_hvt ad=0.1113 pd=1.37 as=0.0882 ps=0.84 w=0.42 l=0.15
X6 a_929_4961# a_231_4595# a_672_4707# VSS.t13 sky130_fd_pr__special_nfet_01v8 ad=0.0684 pd=0.74 as=0.0989 ps=0.995 w=0.36 l=0.15
X7 x3.D a_1561_2214# VDD.t3 VDD.t2 sky130_fd_pr__pfet_01v8 ad=0.29 pd=2.58 as=0.29 ps=2.58 w=1 l=0.15
X8 VDD.t33 x2.VLAT_PLUS x2.VLAT_MINUS VDD.t32 sky130_fd_pr__pfet_01v8 ad=0.29 pd=2.58 as=0.29 ps=2.58 w=1 l=0.15
X9 VSS.t29 x4.Y.t11 a_624_n1852# VSS.t28 sky130_fd_pr__nfet_01v8_lvt ad=0.725 pd=5.29 as=1.45 ps=10.58 w=5 l=1
X10 a_231_4595# a_65_4595# VSS.t7 VSS.t6 sky130_fd_pr__nfet_01v8 ad=0.1092 pd=1.36 as=0.0567 ps=0.69 w=0.42 l=0.15
X11 a_1561_2214# x2.VLAT_MINUS a_929_2214# VSS.t24 sky130_fd_pr__nfet_01v8 ad=0.29 pd=2.58 as=0.29 ps=2.58 w=1 l=0.15
X12 COMP_OUT a_1097_4863# VDD.t21 VDD.t20 sky130_fd_pr__pfet_01v8_hvt ad=0.135 pd=1.27 as=0.135 ps=1.27 w=1 l=0.15
X13 a_624_n1852# VINN a_1570_n570# VSS.t2 sky130_fd_pr__nfet_01v8_lvt ad=0.725 pd=5.29 as=1.45 ps=10.58 w=5 l=1
X14 x4.Y.t0 CLK VDD.t48 VDD.t47 sky130_fd_pr__pfet_01v8_hvt ad=0.14 pd=1.28 as=0.305 ps=2.61 w=1 l=0.15
X15 VDD.t51 CLK x4.Y.t3 VDD.t50 sky130_fd_pr__pfet_01v8_hvt ad=0.14 pd=1.28 as=0.14 ps=1.28 w=1 l=0.15
X16 COMP_OUT a_1097_4863# VSS.t20 VSS.t19 sky130_fd_pr__nfet_01v8 ad=0.08775 pd=0.92 as=0.08775 ps=0.92 w=0.65 l=0.15
X17 VDD.t8 CLK a_65_4595# VDD.t49 sky130_fd_pr__pfet_01v8_hvt ad=0.0864 pd=0.91 as=0.1664 ps=1.8 w=0.64 l=0.15
X18 x2.VLAT_PLUS x4.Y.t17 VDD.t37 VDD.t42 sky130_fd_pr__pfet_01v8 ad=0.825 pd=5.33 as=1.55 ps=10.62 w=5 l=0.15
X19 x2.VLAT_PLUS x2.VLAT_MINUS a_366_n1852# VSS.t25 sky130_fd_pr__nfet_01v8 ad=0.29 pd=2.58 as=0.29 ps=2.58 w=1 l=0.15
X20 x4.Y.t4 CLK VDD.t51 VDD.t52 sky130_fd_pr__pfet_01v8_hvt ad=0.14 pd=1.28 as=0.14 ps=1.28 w=1 l=0.15
X21 VSS.t33 VDD.t58 VSS.t32 VSS.t31 sky130_fd_pr__nfet_01v8 ad=0.143 pd=1.62 as=0 ps=0 w=0.55 l=0.59
X22 a_1570_n570# VINN a_624_n1852# VSS.t3 sky130_fd_pr__nfet_01v8_lvt ad=1.45 pd=10.58 as=0.725 ps=5.29 w=5 l=1
X23 VDD.t45 CLK x4.Y.t1 VDD.t46 sky130_fd_pr__pfet_01v8_hvt ad=0.14 pd=1.28 as=0.14 ps=1.28 w=1 l=0.15
X24 a_932_2929# a_881_2436# VDD.t1 VDD.t0 sky130_fd_pr__pfet_01v8 ad=0.29 pd=2.58 as=0.29 ps=2.58 w=1 l=0.15
X25 VDD.t37 x4.Y.t18 a_366_n1852# VDD.t36 sky130_fd_pr__pfet_01v8 ad=1.55 pd=10.62 as=0.825 ps=5.33 w=5 l=0.15
X26 VDD.t21 a_929_4961# a_1097_4863# VDD.t24 sky130_fd_pr__pfet_01v8_hvt ad=0.135 pd=1.27 as=0.27 ps=2.54 w=1 l=0.15
X27 VDD.t41 x4.Y.t12 a_1570_n570# VDD.t40 sky130_fd_pr__pfet_01v8 ad=1.55 pd=10.62 as=0.825 ps=5.33 w=5 l=0.15
X28 VDD.t54 CLK x4.Y.t5 VDD.t53 sky130_fd_pr__pfet_01v8_hvt ad=0.345 pd=2.69 as=0.14 ps=1.28 w=1 l=0.15
X29 VSS.t20 a_929_4961# a_1097_4863# VSS.t23 sky130_fd_pr__nfet_01v8 ad=0.08775 pd=0.92 as=0.169 ps=1.82 w=0.65 l=0.15
X30 VSS.t36 VDD.t57 VSS.t35 VSS.t34 sky130_fd_pr__nfet_01v8 ad=0.143 pd=1.62 as=0 ps=0 w=0.55 l=0.59
X31 a_504_4961# a_65_4595# a_419_4595# VSS.t8 sky130_fd_pr__special_nfet_01v8 ad=0.0621 pd=0.705 as=0.0813 ps=0.83 w=0.36 l=0.15
X32 VSS.t15 a_672_4707# a_630_4595# VSS.t14 sky130_fd_pr__nfet_01v8 ad=0.12095 pd=1.085 as=0.0696 ps=0.765 w=0.42 l=0.15
X33 x4.Y.t2 CLK VDD.t45 VDD.t44 sky130_fd_pr__pfet_01v8_hvt ad=0.14 pd=1.28 as=0.14 ps=1.28 w=1 l=0.15
X34 a_1561_2214# x2.VLAT_MINUS a_932_2929# VDD.t28 sky130_fd_pr__pfet_01v8 ad=0.29 pd=2.58 as=0.29 ps=2.58 w=1 l=0.15
X35 x2.VLAT_MINUS x4.Y.t15 VDD.t33 VDD.t55 sky130_fd_pr__pfet_01v8 ad=0.825 pd=5.33 as=1.55 ps=10.62 w=5 l=0.15
X36 a_624_n1852# x4.Y.t10 VSS.t29 VSS.t30 sky130_fd_pr__nfet_01v8_lvt ad=1.45 pd=10.58 as=0.725 ps=5.29 w=5 l=1
X37 a_419_4595# x3.D VSS.t11 VSS.t10 sky130_fd_pr__nfet_01v8 ad=0.0813 pd=0.83 as=0.1092 ps=1.36 w=0.42 l=0.15
X38 a_630_4595# a_231_4595# a_504_4961# VSS.t12 sky130_fd_pr__special_nfet_01v8 ad=0.0696 pd=0.765 as=0.0621 ps=0.705 w=0.36 l=0.15
X39 a_929_2214# x2.VLAT_PLUS a_881_2436# VSS.t26 sky130_fd_pr__nfet_01v8 ad=0.29 pd=2.58 as=0.29 ps=2.58 w=1 l=0.15
X40 VDD.t27 VSS.t48 VDD.t26 VDD.t25 sky130_fd_pr__pfet_01v8_hvt ad=0.2262 pd=2.26 as=0 ps=0 w=0.87 l=0.59
X41 a_1570_n570# x2.VLAT_PLUS x2.VLAT_MINUS VSS.t27 sky130_fd_pr__nfet_01v8 ad=0.29 pd=2.58 as=0.29 ps=2.58 w=1 l=0.15
X42 VSS.t7 CLK a_65_4595# VSS.t39 sky130_fd_pr__nfet_01v8 ad=0.0567 pd=0.69 as=0.1092 ps=1.36 w=0.42 l=0.15
X43 VDD.t23 a_1097_4863# COMP_OUT VDD.t22 sky130_fd_pr__pfet_01v8_hvt ad=0.26 pd=2.52 as=0.135 ps=1.27 w=1 l=0.15
X44 VSS.t22 a_1097_4863# COMP_OUT VSS.t21 sky130_fd_pr__nfet_01v8 ad=0.169 pd=1.82 as=0.08775 ps=0.92 w=0.65 l=0.15
X45 a_672_4707# a_504_4961# VSS.t15 VSS.t16 sky130_fd_pr__nfet_01v8 ad=0.0989 pd=0.995 as=0.12095 ps=1.085 w=0.64 l=0.15
X46 a_1055_4595# a_65_4595# a_929_4961# VSS.t9 sky130_fd_pr__special_nfet_01v8 ad=0.066 pd=0.745 as=0.0684 ps=0.74 w=0.36 l=0.15
X47 VSS.t18 a_1097_4863# a_1055_4595# VSS.t17 sky130_fd_pr__nfet_01v8 ad=0.1092 pd=1.36 as=0.066 ps=0.745 w=0.42 l=0.15
X48 x3.D a_1561_2214# VSS.t5 VSS.t4 sky130_fd_pr__nfet_01v8 ad=0.29 pd=2.58 as=0.29 ps=2.58 w=1 l=0.15
X49 a_366_n1852# VINP a_624_n1852# VSS.t46 sky130_fd_pr__nfet_01v8_lvt ad=1.45 pd=10.58 as=0.725 ps=5.29 w=5 l=1
X50 VDD.t6 VSS.t47 VDD.t5 VDD.t4 sky130_fd_pr__pfet_01v8_hvt ad=0.2262 pd=2.26 as=0 ps=0 w=0.87 l=0.59
X51 a_624_n1852# VINP a_366_n1852# VSS.t45 sky130_fd_pr__nfet_01v8_lvt ad=0.725 pd=5.29 as=1.45 ps=10.58 w=5 l=1
X52 a_419_4595# x3.D VDD.t12 VDD.t11 sky130_fd_pr__pfet_01v8_hvt ad=0.05775 pd=0.695 as=0.1092 ps=1.36 w=0.42 l=0.15
X53 VDD.t30 x4.Y.t16 x2.VLAT_PLUS VDD.t43 sky130_fd_pr__pfet_01v8 ad=1.55 pd=10.62 as=0.825 ps=5.33 w=5 l=0.15
X54 a_1013_4961# a_231_4595# a_929_4961# VDD.t14 sky130_fd_pr__pfet_01v8_hvt ad=0.0882 pd=0.84 as=0.0567 ps=0.69 w=0.42 l=0.15
X55 a_599_4961# a_65_4595# a_504_4961# VDD.t9 sky130_fd_pr__pfet_01v8_hvt ad=0.07665 pd=0.785 as=0.06825 ps=0.745 w=0.42 l=0.15
X56 a_932_2929# x2.VLAT_PLUS a_881_2436# VDD.t31 sky130_fd_pr__pfet_01v8 ad=0.29 pd=2.58 as=0.29 ps=2.58 w=1 l=0.15
X57 x4.Y.t8 CLK VSS.t41 VSS.t42 sky130_fd_pr__nfet_01v8 ad=0.0588 pd=0.7 as=0.0588 ps=0.7 w=0.42 l=0.15
X58 x2.VLAT_PLUS x2.VLAT_MINUS VDD.t30 VDD.t29 sky130_fd_pr__pfet_01v8 ad=0.29 pd=2.58 as=0.29 ps=2.58 w=1 l=0.15
X59 VDD.t39 x4.Y.t14 x2.VLAT_MINUS VDD.t38 sky130_fd_pr__pfet_01v8 ad=1.55 pd=10.62 as=0.825 ps=5.33 w=5 l=0.15
X60 a_672_4707# a_504_4961# VDD.t16 VDD.t17 sky130_fd_pr__pfet_01v8_hvt ad=0.1095 pd=1.075 as=0.17887 ps=1.26 w=0.75 l=0.15
X61 VSS.t44 CLK x4.Y.t9 VSS.t43 sky130_fd_pr__nfet_01v8 ad=0.1659 pd=1.63 as=0.0588 ps=0.7 w=0.42 l=0.15
X62 a_231_4595# a_65_4595# VDD.t8 VDD.t7 sky130_fd_pr__pfet_01v8_hvt ad=0.1664 pd=1.8 as=0.0864 ps=0.91 w=0.64 l=0.15
X63 x4.Y.t6 CLK VSS.t38 VSS.t37 sky130_fd_pr__nfet_01v8 ad=0.0588 pd=0.7 as=0.1386 ps=1.5 w=0.42 l=0.15
X64 VSS.t41 CLK x4.Y.t7 VSS.t40 sky130_fd_pr__nfet_01v8 ad=0.0588 pd=0.7 as=0.0588 ps=0.7 w=0.42 l=0.15
X65 a_366_n1852# x4.Y.t19 VDD.t35 VDD.t34 sky130_fd_pr__pfet_01v8 ad=0.825 pd=5.33 as=1.55 ps=10.62 w=5 l=0.15
R0 VDD.n135 VDD.n76 3031.76
R1 VDD.n135 VDD.n75 3031.76
R2 VDD.n126 VDD.n3 3031.76
R3 VDD.n100 VDD.n91 3031.76
R4 VDD.n98 VDD.n91 3031.76
R5 VDD.n120 VDD.n2 3031.76
R6 VDD.n132 VDD.n78 2290.59
R7 VDD.n132 VDD.n77 2290.59
R8 VDD.n93 VDD.n92 2290.59
R9 VDD.n93 VDD.n83 2290.59
R10 VDD.n104 VDD.n81 1510.59
R11 VDD.n106 VDD.n87 1510.59
R12 VDD.n70 VDD.n26 1312.94
R13 VDD.n52 VDD.n46 1312.94
R14 VDD.n128 VDD.n81 1238.82
R15 VDD.n87 VDD.n84 1238.82
R16 VDD.n18 VDD.t4 761.74
R17 VDD.n88 VDD.n85 755.294
R18 VDD.n107 VDD.n85 755.294
R19 VDD.n29 VDD.n28 755.294
R20 VDD.n29 VDD.n25 755.294
R21 VDD.n43 VDD.n42 755.294
R22 VDD.n43 VDD.n40 755.294
R23 VDD.n37 VDD.n32 755.294
R24 VDD.n37 VDD.n34 755.294
R25 VDD.n78 VDD.n76 741.178
R26 VDD.n128 VDD.n78 741.178
R27 VDD.n77 VDD.n75 741.178
R28 VDD.n126 VDD.n77 741.178
R29 VDD.n92 VDD.n84 741.178
R30 VDD.n100 VDD.n92 741.178
R31 VDD.n120 VDD.n83 741.178
R32 VDD.n98 VDD.n83 741.178
R33 VDD.t22 VDD.t25 739.875
R34 VDD.t4 VDD.t53 736.917
R35 VDD.t18 VDD.t24 621.495
R36 VDD.n105 VDD.n104 557.648
R37 VDD.n107 VDD.n105 557.648
R38 VDD.n109 VDD.n107 557.648
R39 VDD.n109 VDD.n106 557.648
R40 VDD.n86 VDD.n81 557.648
R41 VDD.n88 VDD.n86 557.648
R42 VDD.n114 VDD.n88 557.648
R43 VDD.n114 VDD.n87 557.648
R44 VDD.n68 VDD.n28 557.648
R45 VDD.n63 VDD.n28 557.648
R46 VDD.n63 VDD.n32 557.648
R47 VDD.n56 VDD.n32 557.648
R48 VDD.n56 VDD.n42 557.648
R49 VDD.n52 VDD.n42 557.648
R50 VDD.n70 VDD.n25 557.648
R51 VDD.n62 VDD.n25 557.648
R52 VDD.n62 VDD.n34 557.648
R53 VDD.n57 VDD.n34 557.648
R54 VDD.n57 VDD.n40 557.648
R55 VDD.n50 VDD.n40 557.648
R56 VDD.t7 VDD.t11 556.386
R57 VDD.t25 VDD.n23 544.548
R58 VDD.n4 VDD.n8 528.84
R59 VDD.n4 VDD.n9 528.84
R60 VDD.n23 VDD.t47 440.966
R61 VDD.t15 VDD.t17 390.654
R62 VDD.t32 VDD.n115 352.187
R63 VDD.n108 VDD.t29 352.187
R64 VDD.t14 VDD.t18 337.384
R65 VDD.n101 VDD.n90 323.526
R66 VDD.n136 VDD.n74 323.389
R67 VDD.t9 VDD.t15 304.829
R68 VDD.t13 VDD.t9 281.154
R69 VDD.t17 VDD.t10 281.154
R70 VDD.t0 VDD.n27 264.262
R71 VDD.t31 VDD.n27 264.262
R72 VDD.t31 VDD.n33 264.262
R73 VDD.t28 VDD.n33 264.262
R74 VDD.t28 VDD.n41 264.262
R75 VDD.t2 VDD.n41 264.262
R76 VDD.t46 VDD.t47 254.518
R77 VDD.t44 VDD.t46 254.518
R78 VDD.t50 VDD.t44 254.518
R79 VDD.t52 VDD.t50 254.518
R80 VDD.t53 VDD.t52 254.518
R81 VDD.t11 VDD.t13 251.559
R82 VDD.n95 VDD.n90 251.405
R83 VDD.n137 VDD.n136 250.345
R84 VDD.t49 VDD.t7 248.599
R85 VDD.t10 VDD.t14 248.599
R86 VDD.t24 VDD.t20 248.599
R87 VDD.t20 VDD.t22 248.599
R88 VDD.n131 VDD.n130 244.329
R89 VDD.n102 VDD.n89 244.329
R90 VDD.n131 VDD.n80 242.825
R91 VDD.n89 VDD.n82 242.825
R92 VDD.n69 VDD.n26 237.584
R93 VDD.n51 VDD.n46 237.584
R94 VDD.n23 VDD.n22 213.119
R95 VDD.n53 VDD.n45 139.976
R96 VDD.n9 VDD.n103 132.142
R97 VDD.n129 VDD.n8 132.142
R98 VDD.n67 VDD.n66 121.138
R99 VDD.n135 VDD.t34 117.906
R100 VDD.t40 VDD.n91 117.906
R101 VDD.t36 VDD.n133 107.025
R102 VDD.n133 VDD.t42 107.025
R103 VDD.n116 VDD.t43 107.025
R104 VDD.t55 VDD.n118 107.025
R105 VDD.n94 VDD.t38 107.025
R106 VDD.t56 VDD.n94 107.025
R107 VDD.n115 VDD.n86 92.5005
R108 VDD.n111 VDD.n86 92.5005
R109 VDD.n115 VDD.n114 92.5005
R110 VDD.n114 VDD.n113 92.5005
R111 VDD.n109 VDD.n108 92.5005
R112 VDD.n4 VDD.n109 92.5005
R113 VDD.n108 VDD.n105 92.5005
R114 VDD.n4 VDD.n105 92.5005
R115 VDD.n70 VDD.t0 92.5005
R116 VDD.n71 VDD.n70 92.5005
R117 VDD.t31 VDD.n62 92.5005
R118 VDD.n62 VDD.n61 92.5005
R119 VDD.n57 VDD.t28 92.5005
R120 VDD.n58 VDD.n57 92.5005
R121 VDD.n50 VDD.n49 92.5005
R122 VDD.n52 VDD.t2 92.5005
R123 VDD.n53 VDD.n52 92.5005
R124 VDD.t28 VDD.n56 92.5005
R125 VDD.n56 VDD.n55 92.5005
R126 VDD.n63 VDD.t31 92.5005
R127 VDD.n64 VDD.n63 92.5005
R128 VDD.n68 VDD.n67 92.5005
R129 VDD.n47 VDD.n45 83.2475
R130 VDD.n112 VDD.n110 80.5652
R131 VDD.n110 VDD.n4 80.5652
R132 VDD.n38 VDD.n31 80.5652
R133 VDD.n39 VDD.n38 80.5652
R134 VDD.n65 VDD.n30 80.5652
R135 VDD.n35 VDD.n30 80.5652
R136 VDD.n103 VDD.n102 79.0593
R137 VDD.n102 VDD.n101 79.0593
R138 VDD.n130 VDD.n74 79.0593
R139 VDD.n130 VDD.n129 79.0593
R140 VDD.n69 VDD.n68 70.7763
R141 VDD.n51 VDD.n50 70.7763
R142 VDD.n117 VDD.t32 65.0195
R143 VDD.n117 VDD.t29 65.0195
R144 VDD.n54 VDD.n44 61.6559
R145 VDD.n111 VDD.n8 59.4829
R146 VDD.n112 VDD.n111 59.4829
R147 VDD.n113 VDD.n112 59.4829
R148 VDD.n113 VDD.n9 59.4829
R149 VDD.n67 VDD.n65 59.4829
R150 VDD.n65 VDD.n64 59.4829
R151 VDD.n64 VDD.n31 59.4829
R152 VDD.n55 VDD.n31 59.4829
R153 VDD.n55 VDD.n54 59.4829
R154 VDD.n54 VDD.n53 59.4829
R155 VDD.n99 VDD.n98 46.2505
R156 VDD.n98 VDD.n97 46.2505
R157 VDD.n120 VDD.n119 46.2505
R158 VDD.n121 VDD.n120 46.2505
R159 VDD.n119 VDD.n84 46.2505
R160 VDD.n103 VDD.n84 46.2505
R161 VDD.n100 VDD.n99 46.2505
R162 VDD.n101 VDD.n100 46.2505
R163 VDD.n117 VDD.n85 46.2505
R164 VDD.n110 VDD.n85 46.2505
R165 VDD.n128 VDD.n127 46.2505
R166 VDD.n129 VDD.n128 46.2505
R167 VDD.n134 VDD.n76 46.2505
R168 VDD.n76 VDD.n74 46.2505
R169 VDD.n134 VDD.n75 46.2505
R170 VDD.n75 VDD.n73 46.2505
R171 VDD.n127 VDD.n126 46.2505
R172 VDD.n126 VDD.n125 46.2505
R173 VDD.n46 VDD.n45 46.2505
R174 VDD.n66 VDD.n26 46.2505
R175 VDD.n29 VDD.n27 46.2505
R176 VDD.n30 VDD.n29 46.2505
R177 VDD.n43 VDD.n41 46.2505
R178 VDD.n44 VDD.n43 46.2505
R179 VDD.n37 VDD.n33 46.2505
R180 VDD.n38 VDD.n37 46.2505
R181 VDD.n104 VDD.n3 42.3534
R182 VDD.n106 VDD.n2 42.3534
R183 VDD.n117 VDD.n116 35.0144
R184 VDD.n118 VDD.n117 35.0144
R185 VDD VDD.n5 1.7775
R186 VDD.n6 VDD.t16 12.1901
R187 VDD.t34 VDD.n134 31.7112
R188 VDD.n134 VDD.t36 31.7112
R189 VDD.n127 VDD.t42 31.7112
R190 VDD.n127 VDD.t43 31.7112
R191 VDD.n119 VDD.t55 31.7112
R192 VDD.n119 VDD.t38 31.7112
R193 VDD.n99 VDD.t56 31.7112
R194 VDD.n99 VDD.t40 31.7112
R195 VDD.t21 VDD.n10 37.4011
R196 VDD.n16 VDD.t51 32.9936
R197 VDD.n14 VDD.t45 5.38743
R198 VDD.n11 VDD.t23 31.6517
R199 VDD.t45 VDD.n15 29.036
R200 VDD.t49 VDD.n7 631.112
R201 VDD.n5 VDD.t8 28.2428
R202 VDD.t12 VDD.n5 4.17146
R203 VDD.t8 VDD.n7 6.51996
R204 VDD.n15 VDD.t51 4.94188
R205 VDD.n14 VDD.t48 24.9639
R206 VDD.t2 VDD.n51 16.7394
R207 VDD.t0 VDD.n69 16.7394
R208 VDD.n16 VDD.t54 4.38186
R209 VDD.n6 VDD.t19 23.0704
R210 VDD.n72 VDD.t1 14.4208
R211 VDD.t3 VDD.n36 14.4208
R212 VDD.t54 VDD.n20 14.2735
R213 VDD.n22 VDD.t26 14.2735
R214 VDD.n4 VDD.n1 14.2185
R215 VDD.n121 VDD.n82 13.8562
R216 VDD.n125 VDD.n80 13.8562
R217 VDD.n97 VDD.n96 13.3283
R218 VDD.n79 VDD.n73 13.2624
R219 VDD.n13 VDD.t48 3.79208
R220 VDD.n91 VDD.n90 11.0403
R221 VDD.n116 VDD.n3 10.8829
R222 VDD.n4 VDD.n3 10.8829
R223 VDD.n118 VDD.n2 10.8829
R224 VDD.n136 VDD.n135 10.8829
R225 VDD.n133 VDD.n132 10.8829
R226 VDD.n132 VDD.n131 10.8829
R227 VDD.n94 VDD.n93 10.8829
R228 VDD.n93 VDD.n89 10.8829
R229 VDD.n0 VDD.n72 10.5356
R230 VDD.n47 VDD.n0 9.5505
R231 VDD.n124 VDD.t30 9.3005
R232 VDD.n79 VDD.t37 9.3005
R233 VDD.t35 VDD.n137 9.3005
R234 VDD.t41 VDD.n95 9.3005
R235 VDD.n96 VDD.t39 9.3005
R236 VDD.t33 VDD.n122 9.3005
R237 VDD.n24 VDD.n0 9.3005
R238 VDD.n60 VDD.n0 9.3005
R239 VDD.n0 VDD.n17 9.3005
R240 VDD.n0 VDD.n59 9.3005
R241 VDD.n48 VDD.n0 9.3005
R242 VDD.n10 VDD.t19 5.77756
R243 VDD.n10 VDD 1.76272
R244 VDD VDD.n11 1.62567
R245 VDD.n12 VDD 1.97608
R246 VDD VDD.n21 9.3005
R247 VDD VDD.t26 9.3005
R248 VDD.n22 VDD.n13 3.79208
R249 VDD VDD.n13 2.75546
R250 VDD.n14 VDD 1.95779
R251 VDD VDD.n15 2.18056
R252 VDD.n16 VDD 2.46057
R253 VDD.n20 VDD 9.3005
R254 VDD VDD.n19 9.3005
R255 VDD.n12 VDD.t23 14.3861
R256 VDD.n4 VDD.n2 11.5535
R257 VDD.n122 VDD.n1 7.45617
R258 VDD.n124 VDD.n1 7.39019
R259 VDD.n59 VDD.n36 6.77477
R260 VDD.n97 VDD.n95 6.33452
R261 VDD.n137 VDD.n73 6.33452
R262 VDD.n58 VDD.n39 5.91395
R263 VDD.n61 VDD.n17 5.53968
R264 VDD.n122 VDD.n121 5.27885
R265 VDD.n125 VDD.n124 5.21287
R266 VDD.n123 VDD.n1 4.86356
R267 VDD.n19 VDD.t6 4.36875
R268 VDD.n21 VDD.t27 4.36875
R269 VDD.n49 VDD.n47 4.34202
R270 VDD.t5 VDD.n18 4.33016
R271 VDD.n60 VDD.n35 3.96775
R272 VDD.n72 VDD.n71 3.85547
R273 VDD.n35 VDD.n24 3.51863
R274 VDD.n19 VDD.t57 3.50526
R275 VDD.n21 VDD.t58 3.50526
R276 VDD.n49 VDD.n48 3.14436
R277 VDD.n11 VDD.t21 9.06342
R278 VDD.n66 VDD.t1 2.91696
R279 VDD.n44 VDD.t3 2.91696
R280 VDD VDD.n18 2.76497
R281 VDD.n71 VDD.n24 2.39582
R282 VDD.n61 VDD.n60 1.9467
R283 VDD.n59 VDD.n58 1.19816
R284 VDD.t58 VDD.t26 1.16875
R285 VDD.t57 VDD.t5 0.863992
R286 VDD.n48 VDD.n36 0.711611
R287 VDD.n80 VDD.n79 0.594314
R288 VDD.t30 VDD.n123 0.555508
R289 VDD.n123 VDD.t33 0.555508
R290 VDD.n96 VDD.n82 0.528335
R291 VDD.t39 VDD.t41 0.466125
R292 VDD.t30 VDD.t37 0.466125
R293 VDD.t39 VDD.t33 0.466125
R294 VDD.t35 VDD.t37 0.464563
R295 VDD.n39 VDD.n17 0.374769
R296 VDD.n20 VDD.t6 0.305262
R297 VDD.t27 VDD.n12 5.6556
R298 VDD VDD.t35 1.70709
R299 VDD VDD.n0 1.51942
R300 VDD VDD.n6 1.36681
R301 VDD.n7 VDD 1.00149
R302 VSS.n112 VSS.n17 24823.1
R303 VSS.n80 VSS.n17 6156.29
R304 VSS.n112 VSS.n111 6073.79
R305 VSS.n84 VSS.n79 5684.03
R306 VSS.n82 VSS.n79 5684.03
R307 VSS.n110 VSS.n54 5684.03
R308 VSS.n110 VSS.n55 5684.03
R309 VSS.n105 VSS.n60 3425.61
R310 VSS.n105 VSS.n59 3425.61
R311 VSS.n88 VSS.n73 3333.03
R312 VSS.n88 VSS.n69 3333.03
R313 VSS.n124 VSS.n16 2126.44
R314 VSS.n124 VSS.n15 2126.44
R315 VSS.n52 VSS.n19 2126.44
R316 VSS.n52 VSS.n18 2126.44
R317 VSS.n91 VSS.n72 2126.44
R318 VSS.n92 VSS.n72 2126.44
R319 VSS.n102 VSS.n62 2126.44
R320 VSS.n102 VSS.n63 2126.44
R321 VSS.n59 VSS.n54 2056.91
R322 VSS.n94 VSS.n59 2056.91
R323 VSS.n68 VSS.n60 2056.91
R324 VSS.n60 VSS.n55 2056.91
R325 VSS.n94 VSS.n69 2039.53
R326 VSS.n73 VSS.n68 2039.53
R327 VSS.n84 VSS.n73 2039.53
R328 VSS.n82 VSS.n69 2039.53
R329 VSS.n97 VSS.n67 1272.06
R330 VSS.n97 VSS.n66 1272.06
R331 VSS.n28 VSS.n27 1210.97
R332 VSS.n27 VSS.n23 1210.97
R333 VSS.n31 VSS.n29 1210.97
R334 VSS.n31 VSS.n24 1210.97
R335 VSS.n37 VSS.n33 1210.97
R336 VSS.n37 VSS.n35 1210.97
R337 VSS.n122 VSS.n121 1205.01
R338 VSS.n118 VSS.n117 1198.25
R339 VSS.n33 VSS.n16 915.471
R340 VSS.n42 VSS.n33 915.471
R341 VSS.n42 VSS.n29 915.471
R342 VSS.n46 VSS.n29 915.471
R343 VSS.n46 VSS.n28 915.471
R344 VSS.n28 VSS.n19 915.471
R345 VSS.n35 VSS.n15 915.471
R346 VSS.n41 VSS.n35 915.471
R347 VSS.n41 VSS.n24 915.471
R348 VSS.n47 VSS.n24 915.471
R349 VSS.n47 VSS.n23 915.471
R350 VSS.n23 VSS.n18 915.471
R351 VSS.n66 VSS.n62 816.971
R352 VSS.n91 VSS.n66 816.971
R353 VSS.n92 VSS.n67 816.971
R354 VSS.n67 VSS.n63 816.971
R355 VSS.t31 VSS.t21 712.273
R356 VSS.n122 VSS.n17 570.79
R357 VSS.t23 VSS.t17 542.821
R358 VSS.n117 VSS.t31 528.46
R359 VSS.n123 VSS.t0 499.425
R360 VSS.n34 VSS.t0 499.425
R361 VSS.t26 VSS.n34 499.425
R362 VSS.t26 VSS.n26 499.425
R363 VSS.t24 VSS.n26 499.425
R364 VSS.t24 VSS.n25 499.425
R365 VSS.n25 VSS.t4 499.425
R366 VSS.n53 VSS.t4 499.425
R367 VSS.n117 VSS.n116 436.555
R368 VSS.t43 VSS.t34 422.108
R369 VSS.t45 VSS.n80 399.104
R370 VSS.n89 VSS.t46 399.104
R371 VSS.n104 VSS.t2 399.104
R372 VSS.n111 VSS.t3 399.104
R373 VSS.n115 VSS.n112 394.387
R374 VSS.t14 VSS.t16 364.752
R375 VSS.t9 VSS.t13 304.44
R376 VSS.t25 VSS.n91 292.5
R377 VSS.n91 VSS.n64 292.5
R378 VSS.n62 VSS.t27 292.5
R379 VSS.n100 VSS.n62 292.5
R380 VSS.n63 VSS.t27 292.5
R381 VSS.n65 VSS.n63 292.5
R382 VSS.n92 VSS.t25 292.5
R383 VSS.n93 VSS.n92 292.5
R384 VSS.t0 VSS.n15 292.5
R385 VSS.n15 VSS.n14 292.5
R386 VSS.t26 VSS.n41 292.5
R387 VSS.n41 VSS.n40 292.5
R388 VSS.n47 VSS.t24 292.5
R389 VSS.n48 VSS.n47 292.5
R390 VSS.n18 VSS.t4 292.5
R391 VSS.n50 VSS.n18 292.5
R392 VSS.n19 VSS.t4 292.5
R393 VSS.n20 VSS.n19 292.5
R394 VSS.t24 VSS.n46 292.5
R395 VSS.n46 VSS.n45 292.5
R396 VSS.n42 VSS.t26 292.5
R397 VSS.n43 VSS.n42 292.5
R398 VSS.t0 VSS.n16 292.5
R399 VSS.n16 VSS.n13 292.5
R400 VSS.t13 VSS.t16 290.079
R401 VSS.t17 VSS.t9 272.846
R402 VSS.t25 VSS.n90 259.5
R403 VSS.n103 VSS.t27 259.5
R404 VSS.n109 VSS.n56 249.637
R405 VSS.n85 VSS.n78 248.454
R406 VSS.t19 VSS.t23 241.254
R407 VSS.t21 VSS.t19 241.254
R408 VSS.n109 VSS.n108 237.898
R409 VSS.n81 VSS.n78 237.736
R410 VSS.t10 VSS.t6 236.885
R411 VSS.t34 VSS.n115 231.845
R412 VSS.n106 VSS.n58 216.534
R413 VSS.n107 VSS.n106 216.534
R414 VSS.n83 VSS.t45 211.87
R415 VSS.n83 VSS.t46 211.87
R416 VSS.n95 VSS.t28 211.87
R417 VSS.t2 VSS.n61 211.87
R418 VSS.n61 VSS.t3 211.87
R419 VSS.n87 VSS.n86 210.681
R420 VSS.n87 VSS.n74 210.681
R421 VSS.n96 VSS.t30 208.585
R422 VSS.n116 VSS.n53 177.012
R423 VSS.t39 VSS.n122 175.143
R424 VSS.n123 VSS.t14 158.047
R425 VSS.n103 VSS.n102 146.25
R426 VSS.n102 VSS.n101 146.25
R427 VSS.n90 VSS.n72 146.25
R428 VSS.n72 VSS.n71 146.25
R429 VSS.n97 VSS.n96 146.25
R430 VSS.n98 VSS.n97 146.25
R431 VSS.n53 VSS.n52 146.25
R432 VSS.n52 VSS.n51 146.25
R433 VSS.n124 VSS.n123 146.25
R434 VSS.n125 VSS.n124 146.25
R435 VSS.n37 VSS.n34 146.25
R436 VSS.n38 VSS.n37 146.25
R437 VSS.n31 VSS.n26 146.25
R438 VSS.n32 VSS.n31 146.25
R439 VSS.n27 VSS.n25 146.25
R440 VSS.n27 VSS.n21 146.25
R441 VSS.t8 VSS.t10 141.124
R442 VSS.n51 VSS.n50 138.183
R443 VSS.n71 VSS.n64 138.166
R444 VSS.n101 VSS.n100 138.166
R445 VSS.t12 VSS.t8 124.743
R446 VSS.n125 VSS.n14 117.778
R447 VSS.t14 VSS.t12 114.662
R448 VSS.t37 VSS.t40 108.362
R449 VSS.t40 VSS.t42 108.362
R450 VSS.t42 VSS.t43 108.362
R451 VSS.t6 VSS.t39 105.843
R452 VSS.n116 VSS.t37 104.582
R453 VSS.n93 VSS.n70 98.6537
R454 VSS.n65 VSS.n57 98.6537
R455 VSS.n90 VSS.n89 90.3327
R456 VSS.n104 VSS.n103 90.3327
R457 VSS.n51 VSS.n20 85.5375
R458 VSS.n99 VSS.n98 82.6519
R459 VSS.n44 VSS.n32 78.6829
R460 VSS.n32 VSS.n22 78.6829
R461 VSS.n38 VSS.n36 78.6829
R462 VSS.n39 VSS.n38 78.6829
R463 VSS.n98 VSS.n3 76.4348
R464 VSS.n83 VSS.n82 65.0005
R465 VSS.n82 VSS.n81 65.0005
R466 VSS.n95 VSS.n94 65.0005
R467 VSS.n94 VSS.n3 65.0005
R468 VSS.n61 VSS.n54 65.0005
R469 VSS.n108 VSS.n54 65.0005
R470 VSS.n61 VSS.n55 65.0005
R471 VSS.n56 VSS.n55 65.0005
R472 VSS.n95 VSS.n68 65.0005
R473 VSS.n76 VSS.n68 65.0005
R474 VSS.n84 VSS.n83 65.0005
R475 VSS.n85 VSS.n84 65.0005
R476 VSS.n39 VSS.n14 59.4829
R477 VSS.n40 VSS.n39 59.4829
R478 VSS.n40 VSS.n22 59.4829
R479 VSS.n48 VSS.n22 59.4829
R480 VSS.n49 VSS.n48 59.4829
R481 VSS.n50 VSS.n49 59.4829
R482 VSS.n49 VSS.n21 58.2963
R483 VSS.n100 VSS.n99 53.0829
R484 VSS.n99 VSS.n64 53.0829
R485 VSS.t30 VSS.t27 52.5574
R486 VSS.t25 VSS.t28 44.3454
R487 VSS.n111 VSS.n110 36.563
R488 VSS.n110 VSS.n109 36.563
R489 VSS.n80 VSS.n79 36.563
R490 VSS.n79 VSS.n78 36.563
R491 VSS.n89 VSS.n88 36.563
R492 VSS.n88 VSS.n87 36.563
R493 VSS.n105 VSS.n104 36.563
R494 VSS.n106 VSS.n105 36.563
R495 VSS.n2 VSS 1.72683
R496 VSS.t15 VSS.n0 5.08971
R497 VSS.n4 VSS.t20 38.2073
R498 VSS.n5 VSS.t22 32.4046
R499 VSS.n113 VSS.n10 31.3427
R500 VSS.t38 VSS.n7 30.4369
R501 VSS.t41 VSS.n8 28.3642
R502 VSS.t7 VSS.n2 28.3575
R503 VSS.n0 VSS.t18 30.4107
R504 VSS.n9 VSS.t44 23.9
R505 VSS.n71 VSS.n70 18.0711
R506 VSS.n101 VSS.n57 18.0711
R507 VSS.n58 VSS.n56 18.0171
R508 VSS.n126 VSS.t1 17.926
R509 VSS.n86 VSS.n85 17.8722
R510 VSS.n3 VSS.n65 16.1529
R511 VSS.n119 VSS.n118 14.8179
R512 VSS.n115 VSS.n11 1202.37
R513 VSS.n30 VSS.t5 14.4208
R514 VSS.n86 VSS.n77 11.0626
R515 VSS.n3 VSS.n93 16.0513
R516 VSS.n75 VSS.t29 9.55388
R517 VSS.n127 VSS.n12 9.5505
R518 VSS.n11 VSS 2.58917
R519 VSS.n118 VSS.n7 5.21334
R520 VSS VSS.n7 2.04483
R521 VSS.n8 VSS.t38 5.02305
R522 VSS.n8 VSS 2.13997
R523 VSS.t41 VSS.n9 5.45298
R524 VSS VSS.n9 1.92501
R525 VSS.n10 VSS.t44 5.60763
R526 VSS.n10 VSS 1.84768
R527 VSS.n113 VSS 9.3005
R528 VSS VSS.n114 9.3005
R529 VSS VSS.n119 9.3005
R530 VSS.n120 VSS 9.3005
R531 VSS.n6 VSS 1.95183
R532 VSS.n5 VSS 1.62567
R533 VSS VSS.n4 1.73611
R534 VSS.n4 VSS.t18 5.83079
R535 VSS.t11 VSS.n2 4.26202
R536 VSS.n127 VSS.n126 9.3005
R537 VSS.n76 VSS.n75 9.22616
R538 VSS.n75 VSS.n58 8.79144
R539 VSS.n45 VSS.n30 8.38942
R540 VSS.n108 VSS.n107 8.3038
R541 VSS.n6 VSS.t22 13.6817
R542 VSS.n81 VSS.n74 8.23702
R543 VSS.n121 VSS.t7 6.49593
R544 VSS.n36 VSS.n13 6.22327
R545 VSS.n44 VSS.n43 6.22327
R546 VSS.n45 VSS.n44 6.22327
R547 VSS.n120 VSS.t32 5.98311
R548 VSS.n114 VSS.t35 5.98311
R549 VSS.n43 VSS.n12 5.1205
R550 VSS.t48 VSS.n120 4.8005
R551 VSS.n114 VSS.t47 4.8005
R552 VSS.n30 VSS.n20 4.05712
R553 VSS.n1 VSS.t29 4.03175
R554 VSS.n1 VSS.n127 3.97967
R555 VSS.n77 VSS.n76 3.58653
R556 VSS.n96 VSS.n95 3.28531
R557 VSS.n77 VSS.t29 3.11691
R558 VSS.t5 VSS.n21 2.51189
R559 VSS.t1 VSS.n125 2.51189
R560 VSS.t20 VSS.n5 8.31048
R561 VSS.t33 VSS.t48 1.18311
R562 VSS.t47 VSS.t36 1.18311
R563 VSS.n36 VSS.n12 1.10327
R564 VSS.n74 VSS.n70 0.890935
R565 VSS.n107 VSS.n57 0.824152
R566 VSS.n126 VSS.n13 0.551885
R567 VSS.n6 VSS.t33 5.81674
R568 VSS.n119 VSS.t32 0.417891
R569 VSS.t36 VSS.n113 0.417891
R570 VSS.n11 VSS.t35 4.54204
R571 VSS.n121 VSS 1.57208
R572 VSS VSS.n0 1.17831
R573 VSS VSS.n1 1.09461
R574 x4.Y.n12 x4.Y.t15 1043.42
R575 x4.Y.n13 x4.Y.t16 1043.42
R576 x4.Y.n12 x4.Y.t13 1043.25
R577 x4.Y.n13 x4.Y.t18 1043.25
R578 x4.Y.n1 x4.Y.t12 1038.91
R579 x4.Y.n0 x4.Y.t19 1038.91
R580 x4.Y.n1 x4.Y.t14 1038.54
R581 x4.Y.n0 x4.Y.t17 1038.54
R582 x4.Y.n7 x4.Y.n6 312.226
R583 x4.Y.n3 x4.Y.n2 312.226
R584 x4.Y.t4 x4.Y.n16 311.849
R585 x4.Y.n11 x4.Y.t10 214.587
R586 x4.Y.n11 x4.Y.t11 214.587
R587 x4.Y.n9 x4.Y.n4 203.322
R588 x4.Y.n8 x4.Y.n5 202.97
R589 x4.Y.n8 x4.Y.n7 137.036
R590 x4.Y.n10 x4.Y.n9 51.9534
R591 x4.Y.n7 x4.Y.n3 45.5534
R592 x4.Y.n16 x4.Y.n3 45.177
R593 x4.Y.n9 x4.Y.n8 45.177
R594 x4.Y.n5 x4.Y.t6 40.0005
R595 x4.Y.n5 x4.Y.t7 40.0005
R596 x4.Y.n4 x4.Y.t8 40.0005
R597 x4.Y.n4 x4.Y.t9 40.0005
R598 x4.Y.t5 x4.Y.t4 27.5805
R599 x4.Y.n2 x4.Y.t2 27.5805
R600 x4.Y.n2 x4.Y.t3 27.5805
R601 x4.Y.n6 x4.Y.t0 27.5805
R602 x4.Y.n6 x4.Y.t1 27.5805
R603 x4.Y.n15 x4.Y 24.7342
R604 x4.Y.n16 x4.Y 23.4672
R605 x4.Y x4.Y.n10 12.5872
R606 x4.Y x4.Y.n15 10.8805
R607 x4.Y x4.Y.n14 8.47766
R608 x4.Y x4.Y.n11 8.23979
R609 x4.Y.n1 x4.Y.n12 5.898
R610 x4.Y.n0 x4.Y.n13 5.898
R611 x4.Y.n15 x4.Y 3.62717
R612 x4.Y.n10 x4.Y 1.9205
R613 x4.Y.n14 x4.Y.n0 1.19112
R614 x4.Y.n14 x4.Y.n1 1.17863
C0 COMP_OUT VDD 0.32992f
C1 a_366_n1852# x4.Y 0.4439f
C2 a_1570_n570# VDD 1.09956f
C3 a_624_n1852# a_1570_n570# 0.67576f
C4 a_672_4707# VDD 0.14633f
C5 a_929_4961# a_231_4595# 0.11103f
C6 a_624_n1852# VINP 0.6295f
C7 x3.D a_1561_2214# 0.12509f
C8 a_1097_4863# a_929_4961# 0.20625f
C9 x2.VLAT_PLUS x2.VLAT_MINUS 0.62824f
C10 COMP_OUT a_1097_4863# 0.16492f
C11 a_504_4961# VDD 0.20138f
C12 CLK x4.Y 0.55021f
C13 a_366_n1852# VINP 0.73965f
C14 x4.Y x3.D 0.12921f
C15 a_881_2436# a_932_2929# 0.22518f
C16 a_881_2436# a_929_2214# 0.22449f
C17 a_65_4595# VDD 0.54133f
C18 VDD x2.VLAT_MINUS 2.21709f
C19 x2.VLAT_PLUS VDD 2.86174f
C20 a_65_4595# a_231_4595# 0.56881f
C21 COMP_OUT CLK 0.16899f
C22 a_1570_n570# x4.Y 0.46952f
C23 a_624_n1852# VINN 0.62932f
C24 a_366_n1852# x2.VLAT_PLUS 0.37511f
C25 VDD a_231_4595# 0.26697f
C26 x2.VLAT_MINUS a_1561_2214# 0.22003f
C27 a_1097_4863# VDD 0.3741f
C28 a_65_4595# CLK 0.17402f
C29 a_366_n1852# VDD 1.14669f
C30 a_881_2436# x2.VLAT_PLUS 0.20668f
C31 a_624_n1852# a_366_n1852# 0.71601f
C32 x2.VLAT_MINUS x4.Y 1.39741f
C33 x2.VLAT_PLUS x4.Y 1.29721f
C34 VDD a_1561_2214# 0.4545f
C35 a_929_2214# x2.VLAT_PLUS 0.18698f
C36 CLK VDD 1.27007f
C37 a_881_2436# VDD 0.41989f
C38 VDD x3.D 0.86299f
C39 a_672_4707# a_504_4961# 0.16113f
C40 VDD x4.Y 6.03959f
C41 a_1570_n570# x2.VLAT_MINUS 0.59228f
C42 a_932_2929# VDD 0.52337f
C43 a_624_n1852# x4.Y 0.70715f
C44 a_231_4595# x3.D 0.14329f
C45 a_1570_n570# VINN 0.73867f
C46 VDD a_929_4961# 0.16095f
C47 a_65_4595# a_504_4961# 0.16008f
C48 COMP_OUT VSS 0.68259f
C49 VDD VSS 15.7563f
C50 a_624_n1852# VSS 4.55367f
C51 a_1570_n570# VSS 2.88228f
C52 a_366_n1852# VSS 2.66861f
C53 a_929_2214# VSS 3.74644f
C54 x4.Y VSS 7.58798f
C55 a_630_4595# VSS 0.11114f
C56 a_1013_4961# VSS 0.17505f
C57 a_419_4595# VSS 2.0442f
C58 a_672_4707# VSS 0.16304f
C59 x4.Y.n0 VSS 0.50501f
C60 x4.Y.n1 VSS 0.50339f
C61 x4.Y.t0 VSS 0.98935f
C62 x4.Y.n11 VSS 0.68992f
C63 x4.Y.n12 VSS 0.97507f
C64 x4.Y.n13 VSS 0.97507f
C65 x4.Y.n14 VSS 0.25486f
C66 x4.Y.n15 VSS 1.10684f
C67 VSS.t29 VSS 0.93488f
C68 VSS.t5 VSS 1.47217f
C69 VSS.t15 VSS 0.26596f
C70 VSS.t11 VSS 1.0932f
C71 VSS.t1 VSS 0.24551f
C72 VDD.t35 VSS 5.31286f
C73 VDD.n0 VSS 1.39013f
C74 VDD.n1 VSS 0.88145f
C75 VDD.n4 VSS 0.75727f
C76 VDD.n7 VSS 0.14648f
C77 VDD.t47 VSS 0.1006f
C78 VDD.t48 VSS 1.04974f
C79 VDD.t53 VSS 0.1434f
C80 VDD.t4 VSS 0.23229f
C81 VDD.n18 VSS 0.16912f
C82 VDD.t23 VSS 0.15741f
C83 VDD.t19 VSS 0.2176f
C84 VDD.t16 VSS 0.15884f
C85 VDD.t12 VSS 0.77346f
C86 VDD.t21 VSS 0.26704f
C87 VDD.n23 VSS 0.15556f
C88 VDD.t25 VSS 0.18578f
C89 VDD.t22 VSS 0.14298f
C90 VDD.t24 VSS 0.12585f
C91 VDD.t18 VSS 0.13869f
C92 VDD.t15 VSS 0.1006f
C93 VDD.t11 VSS 0.11686f
C94 VDD.t7 VSS 0.11643f
C95 VDD.t49 VSS 0.14626f
C96 VDD.t1 VSS 0.10057f
C97 VDD.n26 VSS 0.20523f
C98 VDD.n27 VSS 0.23936f
C99 VDD.n33 VSS 0.23936f
C100 VDD.n35 VSS 0.10092f
C101 VDD.n36 VSS 0.12872f
C102 VDD.n41 VSS 0.23936f
C103 VDD.t3 VSS 0.33779f
C104 VDD.n46 VSS 0.20523f
C105 VDD.n47 VSS 0.11086f
C106 VDD.t2 VSS 0.26914f
C107 VDD.t28 VSS 0.23936f
C108 VDD.t31 VSS 0.23936f
C109 VDD.t0 VSS 0.26914f
C110 VDD.n72 VSS 0.15449f
C111 VDD.t37 VSS 1.01983f
C112 VDD.t42 VSS 0.4027f
C113 VDD.t43 VSS 0.4027f
C114 VDD.t41 VSS 0.58118f
C115 VDD.t33 VSS 2.66173f
C116 VDD.t39 VSS 1.02339f
C117 VDD.t38 VSS 0.4027f
C118 VDD.t29 VSS 0.16203f
C119 VDD.n91 VSS 0.54549f
C120 VDD.t40 VSS 0.45014f
C121 VDD.n94 VSS 0.62132f
C122 VDD.t56 VSS 0.4027f
C123 VDD.n95 VSS 0.11731f
C124 VDD.n99 VSS 0.18409f
C125 VDD.n108 VSS 0.21113f
C126 VDD.n115 VSS 0.21113f
C127 VDD.t32 VSS 0.16203f
C128 VDD.n116 VSS 0.41229f
C129 VDD.n117 VSS 0.25377f
C130 VDD.n118 VSS 0.41229f
C131 VDD.t55 VSS 0.4027f
C132 VDD.n119 VSS 0.18409f
C133 VDD.n123 VSS 0.42177f
C134 VDD.t30 VSS 0.91464f
C135 VDD.n127 VSS 0.18409f
C136 VDD.n133 VSS 0.62132f
C137 VDD.t36 VSS 0.4027f
C138 VDD.n134 VSS 0.18409f
C139 VDD.t34 VSS 0.45014f
C140 VDD.n135 VSS 0.54514f
C141 VDD.n137 VSS 0.12586f
.ends
