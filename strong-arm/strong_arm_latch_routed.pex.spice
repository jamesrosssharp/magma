* NGSPICE file created from strong_arm_latch_routed.ext - technology: sky130A

.subckt strong_arm_latch_routed VDD CLK VOUT_PLUS VOUT_MINUS VSS VINP VINN
X0 VOUT_MINUS CLK VDD VDD sky130_fd_pr__pfet_01v8 ad=0.825 pd=5.33 as=1.55 ps=10.62 w=5 l=0.15
X1 a_2271_n1633# VINN a_1325_n2915# VSS.t3 sky130_fd_pr__nfet_01v8_lvt ad=1.45 pd=10.58 as=0.725 ps=5.29 w=5 l=1
X2 VOUT_PLUS CLK VDD VDD sky130_fd_pr__pfet_01v8 ad=0.825 pd=5.33 as=1.55 ps=10.62 w=5 l=0.15
X3 a_1325_n2915# VINN a_2271_n1633# VSS.t2 sky130_fd_pr__nfet_01v8_lvt ad=0.725 pd=5.29 as=1.45 ps=10.58 w=5 l=1
X4 VOUT_PLUS VOUT_MINUS a_1067_n2915# VSS.t6 sky130_fd_pr__nfet_01v8 ad=0.29 pd=2.58 as=0.29 ps=2.58 w=1 l=0.15
X5 VDD VOUT_PLUS VOUT_MINUS VDD sky130_fd_pr__pfet_01v8 ad=0.29 pd=2.58 as=0.29 ps=2.58 w=1 l=0.15
X6 VSS CLK a_1325_n2915# VSS.t4 sky130_fd_pr__nfet_01v8_lvt ad=0.725 pd=5.29 as=1.45 ps=10.58 w=5 l=1
X7 a_1067_n2915# VINP a_1325_n2915# VSS.t1 sky130_fd_pr__nfet_01v8_lvt ad=1.45 pd=10.58 as=0.725 ps=5.29 w=5 l=1
X8 a_1325_n2915# VINP a_1067_n2915# VSS.t0 sky130_fd_pr__nfet_01v8_lvt ad=0.725 pd=5.29 as=1.45 ps=10.58 w=5 l=1
X9 VDD CLK a_1067_n2915# VDD sky130_fd_pr__pfet_01v8 ad=1.55 pd=10.62 as=0.825 ps=5.33 w=5 l=0.15
X10 a_2271_n1633# CLK VDD VDD sky130_fd_pr__pfet_01v8 ad=0.825 pd=5.33 as=1.55 ps=10.62 w=5 l=0.15
X11 a_1325_n2915# CLK VSS VSS.t5 sky130_fd_pr__nfet_01v8_lvt ad=1.45 pd=10.58 as=0.725 ps=5.29 w=5 l=1
X12 VDD CLK a_2271_n1633# VDD sky130_fd_pr__pfet_01v8 ad=1.55 pd=10.62 as=0.825 ps=5.33 w=5 l=0.15
X13 VOUT_PLUS VOUT_MINUS VDD VDD sky130_fd_pr__pfet_01v8 ad=0.29 pd=2.58 as=0.29 ps=2.58 w=1 l=0.15
X14 a_2271_n1633# VOUT_PLUS VOUT_MINUS VSS.t7 sky130_fd_pr__nfet_01v8 ad=0.29 pd=2.58 as=0.29 ps=2.58 w=1 l=0.15
X15 VDD CLK VOUT_MINUS VDD sky130_fd_pr__pfet_01v8 ad=1.55 pd=10.62 as=0.825 ps=5.33 w=5 l=0.15
X16 VDD CLK VOUT_PLUS VDD sky130_fd_pr__pfet_01v8 ad=1.55 pd=10.62 as=0.825 ps=5.33 w=5 l=0.15
X17 a_1067_n2915# CLK VDD VDD sky130_fd_pr__pfet_01v8 ad=0.825 pd=5.33 as=1.55 ps=10.62 w=5 l=0.15
R0 VSS.n33 VSS.n32 120868
R1 VSS.n31 VSS.n22 5684.03
R2 VSS.n31 VSS.n23 5684.03
R3 VSS.n36 VSS.n21 5684.03
R4 VSS.n40 VSS.n21 5684.03
R5 VSS.n37 VSS.n6 3425.61
R6 VSS.n37 VSS.n9 3425.61
R7 VSS.n27 VSS.n7 3333.03
R8 VSS.n27 VSS.n10 3333.03
R9 VSS.n49 VSS.n12 2126.44
R10 VSS.n50 VSS.n12 2126.44
R11 VSS.n43 VSS.n17 2126.44
R12 VSS.n44 VSS.n17 2126.44
R13 VSS.n52 VSS.n9 2056.91
R14 VSS.n36 VSS.n6 2056.91
R15 VSS.n54 VSS.n6 2056.91
R16 VSS.n40 VSS.n9 2056.91
R17 VSS.n52 VSS.n10 2039.53
R18 VSS.n22 VSS.n10 2039.53
R19 VSS.n23 VSS.n7 2039.53
R20 VSS.n54 VSS.n7 2039.53
R21 VSS.n15 VSS.n11 1272.06
R22 VSS.n15 VSS.n14 1272.06
R23 VSS.n49 VSS.n14 816.971
R24 VSS.n50 VSS.n11 816.971
R25 VSS.n43 VSS.n11 816.971
R26 VSS.n44 VSS.n14 816.971
R27 VSS.n32 VSS.t0 490.685
R28 VSS.n26 VSS.t1 490.685
R29 VSS.t2 VSS.n38 490.685
R30 VSS.t3 VSS.n33 490.685
R31 VSS.t6 VSS.n13 319.046
R32 VSS.t7 VSS.n18 319.046
R33 VSS.n44 VSS.t7 292.5
R34 VSS.n45 VSS.n44 292.5
R35 VSS.t7 VSS.n43 292.5
R36 VSS.n43 VSS.n42 292.5
R37 VSS.n50 VSS.t6 292.5
R38 VSS.n51 VSS.n50 292.5
R39 VSS.t6 VSS.n49 292.5
R40 VSS.n49 VSS.n48 292.5
R41 VSS.n25 VSS.t0 260.486
R42 VSS.t1 VSS.n25 260.486
R43 VSS.n39 VSS.t2 260.486
R44 VSS.n39 VSS.t3 260.486
R45 VSS.n53 VSS.t4 260.486
R46 VSS.t5 VSS.n8 256.449
R47 VSS.n35 VSS.n20 249.637
R48 VSS.n30 VSS.n24 248.456
R49 VSS.n41 VSS.n20 237.898
R50 VSS.n30 VSS.n29 237.736
R51 VSS.n34 VSS.n19 216.534
R52 VSS.n2 VSS.n19 216.534
R53 VSS.n28 VSS.n5 210.681
R54 VSS.n0 VSS.n28 210.681
R55 VSS.n18 VSS.n17 146.25
R56 VSS.n17 VSS.n1 146.25
R57 VSS.n15 VSS.n8 146.25
R58 VSS.n16 VSS.n15 146.25
R59 VSS.n13 VSS.n12 146.25
R60 VSS.n47 VSS.n12 146.25
R61 VSS.n45 VSS.n1 138.166
R62 VSS.n48 VSS.n47 138.166
R63 VSS.n26 VSS.n13 111.061
R64 VSS.n38 VSS.n18 111.061
R65 VSS.n42 VSS.n2 98.6537
R66 VSS.n51 VSS.n0 98.6537
R67 VSS.n46 VSS.n16 82.6519
R68 VSS.n16 VSS.n3 76.4348
R69 VSS.n39 VSS.n36 65.0005
R70 VSS.n36 VSS.n35 65.0005
R71 VSS.n54 VSS.n53 65.0005
R72 VSS.n55 VSS.n54 65.0005
R73 VSS.n25 VSS.n23 65.0005
R74 VSS.n24 VSS.n23 65.0005
R75 VSS.n25 VSS.n22 65.0005
R76 VSS.n29 VSS.n22 65.0005
R77 VSS.n53 VSS.n52 65.0005
R78 VSS.n52 VSS.n3 65.0005
R79 VSS.n40 VSS.n39 65.0005
R80 VSS.n41 VSS.n40 65.0005
R81 VSS.t7 VSS.t5 64.6173
R82 VSS.t6 VSS.t4 54.5209
R83 VSS.n46 VSS.n45 53.0829
R84 VSS.n48 VSS.n46 53.0829
R85 VSS.n32 VSS.n31 36.563
R86 VSS.n31 VSS.n30 36.563
R87 VSS.n27 VSS.n26 36.563
R88 VSS.n28 VSS.n27 36.563
R89 VSS.n38 VSS.n37 36.563
R90 VSS.n37 VSS.n19 36.563
R91 VSS.n33 VSS.n21 36.563
R92 VSS.n21 VSS.n20 36.563
R93 VSS.n2 VSS.n1 18.0711
R94 VSS.n47 VSS.n0 18.0711
R95 VSS.n35 VSS.n34 18.0171
R96 VSS.n24 VSS.n5 17.8722
R97 VSS.n42 VSS.n3 16.1529
R98 VSS.n3 VSS.n51 16.0513
R99 VSS.n56 VSS.n5 11.0626
R100 VSS VSS.n4 9.55388
R101 VSS.n55 VSS.n4 9.22616
R102 VSS.n2 VSS.n41 9.12746
R103 VSS.n29 VSS.n0 9.12746
R104 VSS.n34 VSS.n4 8.79144
R105 VSS.n53 VSS.n8 4.03905
R106 VSS.n56 VSS.n55 3.58653
R107 VSS VSS.n56 3.11691
C0 VINN a_1325_n2915# 0.65468f
C1 a_1325_n2915# a_1067_n2915# 1.15167f
C2 a_1325_n2915# CLK 0.74231f
C3 VOUT_PLUS VDD 2.87245f
C4 a_1325_n2915# a_2271_n1633# 1.07677f
C5 VOUT_MINUS a_1325_n2915# 0.13604f
C6 VDD a_1067_n2915# 1.86089f
C7 VOUT_PLUS a_1067_n2915# 0.52057f
C8 VDD CLK 5.55416f
C9 VOUT_PLUS CLK 1.10766f
C10 VINP a_1325_n2915# 0.65494f
C11 VDD a_2271_n1633# 1.86867f
C12 VOUT_MINUS VDD 2.6322f
C13 VINN a_2271_n1633# 0.75015f
C14 VOUT_PLUS VOUT_MINUS 0.55884f
C15 CLK a_1067_n2915# 0.70352f
C16 CLK a_2271_n1633# 0.60943f
C17 VOUT_MINUS CLK 1.02892f
C18 VOUT_MINUS a_2271_n1633# 0.79801f
C19 VINP a_1067_n2915# 0.7512f
C20 VOUT_MINUS VSS 0.34843f
C21 VDD VSS 14.83686f
C22 a_1325_n2915# VSS 3.90201f
C23 a_2271_n1633# VSS 3.21533f
C24 a_1067_n2915# VSS 4.50035f
.ends
