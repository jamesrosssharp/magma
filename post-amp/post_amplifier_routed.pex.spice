* NGSPICE file created from post_amplifier_routed.ext - technology: sky130A

.subckt post_amplifier_routed VDD VLAT_PLUS VLAT_MINUS VOUT VSS
X0 VOUT a_2106_n953# VDD VDD sky130_fd_pr__pfet_01v8 ad=0.29 pd=2.58 as=0.29 ps=2.58 w=1 l=0.15
X1 a_1474_n953# VLAT_PLUS a_1426_n731# VSS.t5 sky130_fd_pr__nfet_01v8 ad=0.29 pd=2.58 as=0.29 ps=2.58 w=1 l=0.15
X2 a_2106_n953# VLAT_MINUS a_1477_n238# VDD sky130_fd_pr__pfet_01v8 ad=0.29 pd=2.58 as=0.29 ps=2.58 w=1 l=0.15
X3 a_1474_n953# a_1426_n731# VSS.t2 VSS.t1 sky130_fd_pr__nfet_01v8 ad=0.29 pd=2.58 as=0.29 ps=2.58 w=1 l=0.15
X4 VOUT a_2106_n953# VSS.t4 VSS.t3 sky130_fd_pr__nfet_01v8 ad=0.29 pd=2.58 as=0.29 ps=2.58 w=1 l=0.15
X5 a_1477_n238# VLAT_PLUS a_1426_n731# VDD sky130_fd_pr__pfet_01v8 ad=0.29 pd=2.58 as=0.29 ps=2.58 w=1 l=0.15
X6 a_2106_n953# VLAT_MINUS a_1474_n953# VSS.t0 sky130_fd_pr__nfet_01v8 ad=0.29 pd=2.58 as=0.29 ps=2.58 w=1 l=0.15
X7 a_1477_n238# a_1426_n731# VDD VDD sky130_fd_pr__pfet_01v8 ad=0.29 pd=2.58 as=0.29 ps=2.58 w=1 l=0.15
R0 VSS.n41 VSS.n40 57126.1
R1 VSS.n39 VSS.n6 2126.44
R2 VSS.n42 VSS.n4 2126.44
R3 VSS.n42 VSS.n3 2126.44
R4 VSS.n39 VSS.n5 2126.44
R5 VSS.n15 VSS.n9 1210.97
R6 VSS.n15 VSS.n13 1210.97
R7 VSS.n18 VSS.n10 1210.97
R8 VSS.n18 VSS.n14 1210.97
R9 VSS.n26 VSS.n25 1210.97
R10 VSS.n25 VSS.n21 1210.97
R11 VSS.n26 VSS.n4 915.471
R12 VSS.n28 VSS.n26 915.471
R13 VSS.n28 VSS.n10 915.471
R14 VSS.n34 VSS.n10 915.471
R15 VSS.n34 VSS.n9 915.471
R16 VSS.n9 VSS.n6 915.471
R17 VSS.n21 VSS.n3 915.471
R18 VSS.n29 VSS.n21 915.471
R19 VSS.n29 VSS.n14 915.471
R20 VSS.n33 VSS.n14 915.471
R21 VSS.n33 VSS.n13 915.471
R22 VSS.n13 VSS.n5 915.471
R23 VSS.n41 VSS.t1 764.798
R24 VSS.n22 VSS.t1 764.798
R25 VSS.t5 VSS.n22 764.798
R26 VSS.t5 VSS.n12 764.798
R27 VSS.t0 VSS.n12 764.798
R28 VSS.t0 VSS.n11 764.798
R29 VSS.n11 VSS.t3 764.798
R30 VSS.n40 VSS.t3 764.798
R31 VSS.n6 VSS.t3 292.5
R32 VSS.n37 VSS.n6 292.5
R33 VSS.n34 VSS.t0 292.5
R34 VSS.n35 VSS.n34 292.5
R35 VSS.t5 VSS.n28 292.5
R36 VSS.n28 VSS.n27 292.5
R37 VSS.t1 VSS.n4 292.5
R38 VSS.n4 VSS.n0 292.5
R39 VSS.t1 VSS.n3 292.5
R40 VSS.n3 VSS.n2 292.5
R41 VSS.n29 VSS.t5 292.5
R42 VSS.n30 VSS.n29 292.5
R43 VSS.t0 VSS.n33 292.5
R44 VSS.n33 VSS.n32 292.5
R45 VSS.n5 VSS.t3 292.5
R46 VSS.n7 VSS.n5 292.5
R47 VSS.n42 VSS.n41 146.25
R48 VSS.n43 VSS.n42 146.25
R49 VSS.n40 VSS.n39 146.25
R50 VSS.n39 VSS.n38 146.25
R51 VSS.n15 VSS.n11 146.25
R52 VSS.n16 VSS.n15 146.25
R53 VSS.n25 VSS.n22 146.25
R54 VSS.n25 VSS.n24 146.25
R55 VSS.n18 VSS.n12 146.25
R56 VSS.n19 VSS.n18 146.25
R57 VSS.n38 VSS.n7 138.184
R58 VSS.n43 VSS.n2 117.778
R59 VSS.n38 VSS.n37 85.5375
R60 VSS.n19 VSS.n8 78.6829
R61 VSS.n31 VSS.n19 78.6829
R62 VSS.n24 VSS.n23 78.6829
R63 VSS.n24 VSS.n20 78.6829
R64 VSS.n20 VSS.n2 59.4829
R65 VSS.n30 VSS.n20 59.4829
R66 VSS.n31 VSS.n30 59.4829
R67 VSS.n32 VSS.n31 59.4829
R68 VSS.n32 VSS.n17 59.4829
R69 VSS.n17 VSS.n7 59.4829
R70 VSS.n17 VSS.n16 58.2963
R71 VSS.n0 VSS.t2 17.926
R72 VSS.n36 VSS.t4 14.4208
R73 VSS VSS.n1 9.5505
R74 VSS VSS.n0 9.3005
R75 VSS.n36 VSS.n35 8.38942
R76 VSS.n23 VSS.n0 6.77465
R77 VSS.n27 VSS.n8 6.22327
R78 VSS.n35 VSS.n8 6.22327
R79 VSS.n27 VSS.n1 5.1205
R80 VSS.n37 VSS.n36 4.05712
R81 VSS.t2 VSS.n43 2.51189
R82 VSS.n16 VSS.t4 2.51189
R83 VSS.n23 VSS.n1 1.10327
C0 a_1426_n731# a_1477_n238# 0.3501f
C1 a_1474_n953# VLAT_PLUS 0.21324f
C2 VLAT_MINUS a_2106_n953# 0.31867f
C3 VOUT a_2106_n953# 0.20916f
C4 a_2106_n953# a_1477_n238# 0.17077f
C5 a_1426_n731# a_1474_n953# 0.34901f
C6 VLAT_PLUS VDD 0.23862f
C7 a_1474_n953# a_2106_n953# 0.17079f
C8 a_1426_n731# VDD 0.47793f
C9 VLAT_MINUS VDD 0.24196f
C10 a_1426_n731# VLAT_PLUS 0.30644f
C11 VLAT_MINUS VLAT_PLUS 0.3715f
C12 VOUT VDD 0.40049f
C13 a_1477_n238# VDD 0.74486f
C14 a_2106_n953# VDD 0.55035f
C15 VOUT VSS 1.19004f
C16 VDD VSS 3.9495f
C17 a_1474_n953# VSS 1.75221f
C18 a_1477_n238# VSS 0.52881f
C19 VSS.t4 VSS 0.22908f
C20 VSS.t2 VSS 0.52749f
.ends
