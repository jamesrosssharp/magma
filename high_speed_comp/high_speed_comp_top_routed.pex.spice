* NGSPICE file created from high_speed_comp_top_routed.ext - technology: sky130A

.subckt high_speed_comp_top_routed VINP VINN VDD VSS CLK COMP_OUT
X0 a_504_4961# VDD VDD VDD sky130_fd_pr__pfet_01v8_hvt ad=0.06825 pd=0.745 as=0.05775 ps=0.695 w=0.42 l=0.15
X1 VDD VDD a_599_4961# VDD sky130_fd_pr__pfet_01v8_hvt ad=0.17887 pd=1.26 as=0.07665 ps=0.785 w=0.42 l=0.15
X2 a_1570_n570# x4.Y.t13 VDD VDD sky130_fd_pr__pfet_01v8 ad=0.825 pd=5.33 as=1.55 ps=10.62 w=5 l=0.15
X3 a_929_2214# a_881_2436# VSS.t1 VSS.t0 sky130_fd_pr__nfet_01v8 ad=0.29 pd=2.58 as=0.29 ps=2.58 w=1 l=0.15
X4 a_929_4961# VDD VDD VDD sky130_fd_pr__pfet_01v8_hvt ad=0.0567 pd=0.69 as=0.1095 ps=1.075 w=0.42 l=0.15
X5 VDD VDD a_1013_4961# VDD sky130_fd_pr__pfet_01v8_hvt ad=0.1113 pd=1.37 as=0.0882 ps=0.84 w=0.42 l=0.15
X6 a_929_4961# VDD VDD VSS.t29 sky130_fd_pr__special_nfet_01v8 ad=0.0684 pd=0.74 as=0.0989 ps=0.995 w=0.36 l=0.15
X7 x3.D a_1561_2214# VDD VDD sky130_fd_pr__pfet_01v8 ad=0.29 pd=2.58 as=0.29 ps=2.58 w=1 l=0.15
X8 VDD x2.VLAT_PLUS x2.VLAT_MINUS VDD sky130_fd_pr__pfet_01v8 ad=0.29 pd=2.58 as=0.29 ps=2.58 w=1 l=0.15
X9 VSS.t7 x4.Y.t11 a_624_n1852# VSS.t20 sky130_fd_pr__nfet_01v8_lvt ad=0.725 pd=5.29 as=1.45 ps=10.58 w=5 l=1
X10 VDD VDD VSS.t25 VSS.t24 sky130_fd_pr__nfet_01v8 ad=0.1092 pd=1.36 as=0.0567 ps=0.69 w=0.42 l=0.15
X11 a_1561_2214# x2.VLAT_MINUS a_929_2214# VSS.t14 sky130_fd_pr__nfet_01v8 ad=0.29 pd=2.58 as=0.29 ps=2.58 w=1 l=0.15
X12 COMP_OUT VDD VDD VDD sky130_fd_pr__pfet_01v8_hvt ad=0.135 pd=1.27 as=0.135 ps=1.27 w=1 l=0.15
X13 a_624_n1852# VINN a_1570_n570# VSS.t10 sky130_fd_pr__nfet_01v8_lvt ad=0.725 pd=5.29 as=1.45 ps=10.58 w=5 l=1
X14 x4.Y.t4 CLK VDD VDD sky130_fd_pr__pfet_01v8_hvt ad=0.14 pd=1.28 as=0.305 ps=2.61 w=1 l=0.15
X15 VDD CLK x4.Y.t7 VDD sky130_fd_pr__pfet_01v8_hvt ad=0.14 pd=1.28 as=0.14 ps=1.28 w=1 l=0.15
X16 COMP_OUT VDD VSS.t17 VSS.t33 sky130_fd_pr__nfet_01v8 ad=0.08775 pd=0.92 as=0.08775 ps=0.92 w=0.65 l=0.15
X17 VDD CLK VDD VDD sky130_fd_pr__pfet_01v8_hvt ad=0.1664 pd=1.8 as=17.89315 ps=136.55 w=0.64 l=0.15
X18 x2.VLAT_PLUS x4.Y.t17 VDD VDD sky130_fd_pr__pfet_01v8 ad=0.825 pd=5.33 as=1.55 ps=10.62 w=5 l=0.15
X19 x2.VLAT_PLUS x2.VLAT_MINUS a_366_n1852# VSS.t15 sky130_fd_pr__nfet_01v8 ad=0.29 pd=2.58 as=0.29 ps=2.58 w=1 l=0.15
X20 x4.Y.t8 CLK VDD VDD sky130_fd_pr__pfet_01v8_hvt ad=0.14 pd=1.28 as=0.14 ps=1.28 w=1 l=0.15
X21 VSS.t38 VDD VSS.t37 VSS.t36 sky130_fd_pr__nfet_01v8 ad=0.143 pd=1.62 as=0 ps=0 w=0.55 l=0.59
X22 a_1570_n570# VINN a_624_n1852# VSS.t11 sky130_fd_pr__nfet_01v8_lvt ad=1.45 pd=10.58 as=0.725 ps=5.29 w=5 l=1
X23 VDD CLK x4.Y.t5 VDD sky130_fd_pr__pfet_01v8_hvt ad=0.14 pd=1.28 as=0.14 ps=1.28 w=1 l=0.15
X24 a_932_2929# a_881_2436# VDD VDD sky130_fd_pr__pfet_01v8 ad=0.29 pd=2.58 as=0.29 ps=2.58 w=1 l=0.15
X25 VDD x4.Y.t18 a_366_n1852# VDD sky130_fd_pr__pfet_01v8 ad=1.55 pd=10.62 as=0.825 ps=5.33 w=5 l=0.15
X26 VDD a_929_4961# VDD VDD sky130_fd_pr__pfet_01v8_hvt ad=0.27 pd=2.54 as=0 ps=0 w=1 l=0.15
X27 VDD x4.Y.t12 a_1570_n570# VDD sky130_fd_pr__pfet_01v8 ad=1.55 pd=10.62 as=0.825 ps=5.33 w=5 l=0.15
X28 VDD CLK x4.Y.t9 VDD sky130_fd_pr__pfet_01v8_hvt ad=0.345 pd=2.69 as=0.14 ps=1.28 w=1 l=0.15
X29 VSS.t17 a_929_4961# VDD VSS.t16 sky130_fd_pr__nfet_01v8 ad=0.08775 pd=0.92 as=0.169 ps=1.82 w=0.65 l=0.15
X30 VSS.t23 VDD VSS.t22 VSS.t21 sky130_fd_pr__nfet_01v8 ad=0.143 pd=1.62 as=0 ps=0 w=0.55 l=0.59
X31 a_504_4961# VDD VDD VSS.t26 sky130_fd_pr__special_nfet_01v8 ad=0.0621 pd=0.705 as=0.0813 ps=0.83 w=0.36 l=0.15
X32 VSS.t19 VDD a_630_4595# VSS.t28 sky130_fd_pr__nfet_01v8 ad=0.12095 pd=1.085 as=0.0696 ps=0.765 w=0.42 l=0.15
X33 x4.Y.t6 CLK VDD VDD sky130_fd_pr__pfet_01v8_hvt ad=0.14 pd=1.28 as=0.14 ps=1.28 w=1 l=0.15
X34 a_1561_2214# x2.VLAT_MINUS a_932_2929# VDD sky130_fd_pr__pfet_01v8 ad=0.29 pd=2.58 as=0.29 ps=2.58 w=1 l=0.15
X35 x2.VLAT_MINUS x4.Y.t15 VDD VDD sky130_fd_pr__pfet_01v8 ad=0.825 pd=5.33 as=1.55 ps=10.62 w=5 l=0.15
X36 a_624_n1852# x4.Y.t10 VSS.t7 VSS.t6 sky130_fd_pr__nfet_01v8_lvt ad=1.45 pd=10.58 as=0.725 ps=5.29 w=5 l=1
X37 VDD x3.D VSS.t5 VSS.t4 sky130_fd_pr__nfet_01v8 ad=0.0813 pd=0.83 as=0.1092 ps=1.36 w=0.42 l=0.15
X38 a_630_4595# VDD a_504_4961# VSS.t27 sky130_fd_pr__special_nfet_01v8 ad=0.0696 pd=0.765 as=0.0621 ps=0.705 w=0.36 l=0.15
X39 a_929_2214# x2.VLAT_PLUS a_881_2436# VSS.t8 sky130_fd_pr__nfet_01v8 ad=0.29 pd=2.58 as=0.29 ps=2.58 w=1 l=0.15
X40 VDD VSS.t48 VDD VDD sky130_fd_pr__pfet_01v8_hvt ad=0.2262 pd=2.26 as=0 ps=0 w=0.87 l=0.59
X41 a_1570_n570# x2.VLAT_PLUS x2.VLAT_MINUS VSS.t9 sky130_fd_pr__nfet_01v8 ad=0.29 pd=2.58 as=0.29 ps=2.58 w=1 l=0.15
X42 VSS.t25 CLK VDD VSS.t41 sky130_fd_pr__nfet_01v8 ad=0.0567 pd=0.69 as=0.1092 ps=1.36 w=0.42 l=0.15
X43 VDD VDD COMP_OUT VDD sky130_fd_pr__pfet_01v8_hvt ad=0.26 pd=2.52 as=0.135 ps=1.27 w=1 l=0.15
X44 VSS.t35 VDD COMP_OUT VSS.t34 sky130_fd_pr__nfet_01v8 ad=0.169 pd=1.82 as=0.08775 ps=0.92 w=0.65 l=0.15
X45 VDD a_504_4961# VSS.t19 VSS.t18 sky130_fd_pr__nfet_01v8 ad=0.0989 pd=0.995 as=0.12095 ps=1.085 w=0.64 l=0.15
X46 a_1055_4595# VDD a_929_4961# VSS.t30 sky130_fd_pr__special_nfet_01v8 ad=0.066 pd=0.745 as=0.0684 ps=0.74 w=0.36 l=0.15
X47 VSS.t32 VDD a_1055_4595# VSS.t31 sky130_fd_pr__nfet_01v8 ad=0.1092 pd=1.36 as=0.066 ps=0.745 w=0.42 l=0.15
X48 x3.D a_1561_2214# VSS.t13 VSS.t12 sky130_fd_pr__nfet_01v8 ad=0.29 pd=2.58 as=0.29 ps=2.58 w=1 l=0.15
X49 a_366_n1852# VINP a_624_n1852# VSS.t3 sky130_fd_pr__nfet_01v8_lvt ad=1.45 pd=10.58 as=0.725 ps=5.29 w=5 l=1
X50 VDD VSS.t47 VDD VDD sky130_fd_pr__pfet_01v8_hvt ad=0.2262 pd=2.26 as=0 ps=0 w=0.87 l=0.59
X51 a_624_n1852# VINP a_366_n1852# VSS.t2 sky130_fd_pr__nfet_01v8_lvt ad=0.725 pd=5.29 as=1.45 ps=10.58 w=5 l=1
X52 VDD x3.D VDD VDD sky130_fd_pr__pfet_01v8_hvt ad=0.1092 pd=1.36 as=0 ps=0 w=0.42 l=0.15
X53 VDD x4.Y.t16 x2.VLAT_PLUS VDD sky130_fd_pr__pfet_01v8 ad=1.55 pd=10.62 as=0.825 ps=5.33 w=5 l=0.15
X54 a_1013_4961# VDD a_929_4961# VDD sky130_fd_pr__pfet_01v8_hvt ad=0.0882 pd=0.84 as=0.0567 ps=0.69 w=0.42 l=0.15
X55 a_599_4961# VDD a_504_4961# VDD sky130_fd_pr__pfet_01v8_hvt ad=0.07665 pd=0.785 as=0.06825 ps=0.745 w=0.42 l=0.15
X56 a_932_2929# x2.VLAT_PLUS a_881_2436# VDD sky130_fd_pr__pfet_01v8 ad=0.29 pd=2.58 as=0.29 ps=2.58 w=1 l=0.15
X57 x4.Y.t2 CLK VSS.t45 VSS.t46 sky130_fd_pr__nfet_01v8 ad=0.0588 pd=0.7 as=0.0588 ps=0.7 w=0.42 l=0.15
X58 x2.VLAT_PLUS x2.VLAT_MINUS VDD VDD sky130_fd_pr__pfet_01v8 ad=0.29 pd=2.58 as=0.29 ps=2.58 w=1 l=0.15
X59 VDD x4.Y.t14 x2.VLAT_MINUS VDD sky130_fd_pr__pfet_01v8 ad=1.55 pd=10.62 as=0.825 ps=5.33 w=5 l=0.15
X60 VDD a_504_4961# VDD VDD sky130_fd_pr__pfet_01v8_hvt ad=0.17887 pd=1.26 as=0 ps=0 w=0.75 l=0.15
X61 VSS.t43 CLK x4.Y.t3 VSS.t42 sky130_fd_pr__nfet_01v8 ad=0.1659 pd=1.63 as=0.0588 ps=0.7 w=0.42 l=0.15
X62 VDD VDD VDD VDD sky130_fd_pr__pfet_01v8_hvt ad=0.0864 pd=0.91 as=0 ps=0 w=0.64 l=0.15
X63 x4.Y.t0 CLK VSS.t40 VSS.t39 sky130_fd_pr__nfet_01v8 ad=0.0588 pd=0.7 as=0.1386 ps=1.5 w=0.42 l=0.15
X64 VSS.t45 CLK x4.Y.t1 VSS.t44 sky130_fd_pr__nfet_01v8 ad=0.0588 pd=0.7 as=0.0588 ps=0.7 w=0.42 l=0.15
X65 a_366_n1852# x4.Y.t19 VDD VDD sky130_fd_pr__pfet_01v8 ad=0.825 pd=5.33 as=1.55 ps=10.62 w=5 l=0.15
R0 VSS.n76 VSS.n16 24823.1
R1 VSS.n44 VSS.n16 6156.29
R2 VSS.n76 VSS.n75 6073.79
R3 VSS.n48 VSS.n43 5684.03
R4 VSS.n46 VSS.n43 5684.03
R5 VSS.n74 VSS.n18 5684.03
R6 VSS.n74 VSS.n19 5684.03
R7 VSS.n69 VSS.n24 3425.61
R8 VSS.n69 VSS.n23 3425.61
R9 VSS.n52 VSS.n37 3333.03
R10 VSS.n52 VSS.n33 3333.03
R11 VSS.n124 VSS.n15 2126.44
R12 VSS.n124 VSS.n14 2126.44
R13 VSS.n111 VSS.n78 2126.44
R14 VSS.n111 VSS.n77 2126.44
R15 VSS.n55 VSS.n36 2126.44
R16 VSS.n56 VSS.n36 2126.44
R17 VSS.n66 VSS.n26 2126.44
R18 VSS.n66 VSS.n27 2126.44
R19 VSS.n23 VSS.n18 2056.91
R20 VSS.n58 VSS.n23 2056.91
R21 VSS.n32 VSS.n24 2056.91
R22 VSS.n24 VSS.n19 2056.91
R23 VSS.n58 VSS.n33 2039.53
R24 VSS.n37 VSS.n32 2039.53
R25 VSS.n48 VSS.n37 2039.53
R26 VSS.n46 VSS.n33 2039.53
R27 VSS.n61 VSS.n31 1272.06
R28 VSS.n61 VSS.n30 1272.06
R29 VSS.n87 VSS.n86 1210.97
R30 VSS.n86 VSS.n82 1210.97
R31 VSS.n90 VSS.n88 1210.97
R32 VSS.n90 VSS.n83 1210.97
R33 VSS.n96 VSS.n92 1210.97
R34 VSS.n96 VSS.n94 1210.97
R35 VSS.n122 VSS.n121 1190.61
R36 VSS.n118 VSS.n17 1186.99
R37 VSS.n10 VSS.n114 1190.2
R38 VSS.n92 VSS.n15 915.471
R39 VSS.n101 VSS.n92 915.471
R40 VSS.n101 VSS.n88 915.471
R41 VSS.n105 VSS.n88 915.471
R42 VSS.n105 VSS.n87 915.471
R43 VSS.n87 VSS.n78 915.471
R44 VSS.n94 VSS.n14 915.471
R45 VSS.n100 VSS.n94 915.471
R46 VSS.n100 VSS.n83 915.471
R47 VSS.n106 VSS.n83 915.471
R48 VSS.n106 VSS.n82 915.471
R49 VSS.n82 VSS.n77 915.471
R50 VSS.n30 VSS.n26 816.971
R51 VSS.n55 VSS.n30 816.971
R52 VSS.n56 VSS.n31 816.971
R53 VSS.n31 VSS.n27 816.971
R54 VSS.t36 VSS.t34 712.273
R55 VSS.n122 VSS.n16 570.79
R56 VSS.t16 VSS.t31 542.821
R57 VSS.n17 VSS.t36 528.46
R58 VSS.n123 VSS.t0 499.425
R59 VSS.n93 VSS.t0 499.425
R60 VSS.t8 VSS.n93 499.425
R61 VSS.t8 VSS.n85 499.425
R62 VSS.t14 VSS.n85 499.425
R63 VSS.t14 VSS.n84 499.425
R64 VSS.n84 VSS.t12 499.425
R65 VSS.n112 VSS.t12 499.425
R66 VSS.n113 VSS.n17 436.555
R67 VSS.t21 VSS.t42 422.108
R68 VSS.t2 VSS.n44 399.104
R69 VSS.n53 VSS.t3 399.104
R70 VSS.n68 VSS.t10 399.104
R71 VSS.n75 VSS.t11 399.104
R72 VSS.n114 VSS.n76 394.387
R73 VSS.t28 VSS.t18 364.752
R74 VSS.t30 VSS.t29 304.44
R75 VSS.t15 VSS.n55 292.5
R76 VSS.n55 VSS.n28 292.5
R77 VSS.n26 VSS.t9 292.5
R78 VSS.n64 VSS.n26 292.5
R79 VSS.n27 VSS.t9 292.5
R80 VSS.n29 VSS.n27 292.5
R81 VSS.n56 VSS.t15 292.5
R82 VSS.n57 VSS.n56 292.5
R83 VSS.t0 VSS.n14 292.5
R84 VSS.n14 VSS.n13 292.5
R85 VSS.t8 VSS.n100 292.5
R86 VSS.n100 VSS.n99 292.5
R87 VSS.n106 VSS.t14 292.5
R88 VSS.n107 VSS.n106 292.5
R89 VSS.n77 VSS.t12 292.5
R90 VSS.n109 VSS.n77 292.5
R91 VSS.n78 VSS.t12 292.5
R92 VSS.n79 VSS.n78 292.5
R93 VSS.t14 VSS.n105 292.5
R94 VSS.n105 VSS.n104 292.5
R95 VSS.n101 VSS.t8 292.5
R96 VSS.n102 VSS.n101 292.5
R97 VSS.t0 VSS.n15 292.5
R98 VSS.n15 VSS.n12 292.5
R99 VSS.t29 VSS.t18 290.079
R100 VSS.t31 VSS.t30 272.846
R101 VSS.t15 VSS.n54 259.5
R102 VSS.n67 VSS.t9 259.5
R103 VSS.n73 VSS.n20 249.637
R104 VSS.n49 VSS.n42 248.454
R105 VSS.t33 VSS.t16 241.254
R106 VSS.t34 VSS.t33 241.254
R107 VSS.n73 VSS.n72 237.898
R108 VSS.n45 VSS.n42 237.736
R109 VSS.t4 VSS.t24 236.885
R110 VSS.n114 VSS.t21 231.845
R111 VSS.n70 VSS.n22 216.534
R112 VSS.n71 VSS.n70 216.534
R113 VSS.n47 VSS.t2 211.87
R114 VSS.n47 VSS.t3 211.87
R115 VSS.n59 VSS.t20 211.87
R116 VSS.t10 VSS.n25 211.87
R117 VSS.n25 VSS.t11 211.87
R118 VSS.n51 VSS.n50 210.681
R119 VSS.n51 VSS.n38 210.681
R120 VSS.n60 VSS.t6 208.585
R121 VSS.n113 VSS.n112 177.012
R122 VSS.t41 VSS.n122 175.143
R123 VSS.n123 VSS.t28 158.047
R124 VSS.n67 VSS.n66 146.25
R125 VSS.n66 VSS.n65 146.25
R126 VSS.n54 VSS.n36 146.25
R127 VSS.n36 VSS.n35 146.25
R128 VSS.n61 VSS.n60 146.25
R129 VSS.n62 VSS.n61 146.25
R130 VSS.n112 VSS.n111 146.25
R131 VSS.n111 VSS.n110 146.25
R132 VSS.n124 VSS.n123 146.25
R133 VSS.n125 VSS.n124 146.25
R134 VSS.n96 VSS.n93 146.25
R135 VSS.n97 VSS.n96 146.25
R136 VSS.n90 VSS.n85 146.25
R137 VSS.n91 VSS.n90 146.25
R138 VSS.n86 VSS.n84 146.25
R139 VSS.n86 VSS.n80 146.25
R140 VSS.t26 VSS.t4 141.124
R141 VSS.n110 VSS.n109 138.183
R142 VSS.n35 VSS.n28 138.166
R143 VSS.n65 VSS.n64 138.166
R144 VSS.t27 VSS.t26 124.743
R145 VSS.n125 VSS.n13 117.778
R146 VSS.t28 VSS.t27 114.662
R147 VSS.t44 VSS.t39 108.362
R148 VSS.t46 VSS.t44 108.362
R149 VSS.t42 VSS.t46 108.362
R150 VSS.t24 VSS.t41 105.843
R151 VSS.t39 VSS.n113 104.582
R152 VSS.n57 VSS.n34 98.6537
R153 VSS.n29 VSS.n21 98.6537
R154 VSS.n54 VSS.n53 90.3327
R155 VSS.n68 VSS.n67 90.3327
R156 VSS.n110 VSS.n79 85.5375
R157 VSS.n63 VSS.n62 82.6519
R158 VSS.n103 VSS.n91 78.6829
R159 VSS.n91 VSS.n81 78.6829
R160 VSS.n97 VSS.n95 78.6829
R161 VSS.n98 VSS.n97 78.6829
R162 VSS.n62 VSS.n5 76.4348
R163 VSS.n47 VSS.n46 65.0005
R164 VSS.n46 VSS.n45 65.0005
R165 VSS.n59 VSS.n58 65.0005
R166 VSS.n58 VSS.n5 65.0005
R167 VSS.n25 VSS.n18 65.0005
R168 VSS.n72 VSS.n18 65.0005
R169 VSS.n25 VSS.n19 65.0005
R170 VSS.n20 VSS.n19 65.0005
R171 VSS.n59 VSS.n32 65.0005
R172 VSS.n40 VSS.n32 65.0005
R173 VSS.n48 VSS.n47 65.0005
R174 VSS.n49 VSS.n48 65.0005
R175 VSS.n98 VSS.n13 59.4829
R176 VSS.n99 VSS.n98 59.4829
R177 VSS.n99 VSS.n81 59.4829
R178 VSS.n107 VSS.n81 59.4829
R179 VSS.n108 VSS.n107 59.4829
R180 VSS.n109 VSS.n108 59.4829
R181 VSS.n108 VSS.n80 58.2963
R182 VSS.n64 VSS.n63 53.0829
R183 VSS.n63 VSS.n28 53.0829
R184 VSS.t6 VSS.t9 52.5574
R185 VSS.t15 VSS.t20 44.3454
R186 VSS.n75 VSS.n74 36.563
R187 VSS.n74 VSS.n73 36.563
R188 VSS.n44 VSS.n43 36.563
R189 VSS.n43 VSS.n42 36.563
R190 VSS.n53 VSS.n52 36.563
R191 VSS.n52 VSS.n51 36.563
R192 VSS.n69 VSS.n68 36.563
R193 VSS.n70 VSS.n69 36.563
R194 VSS.n35 VSS.n34 18.0711
R195 VSS.n65 VSS.n21 18.0711
R196 VSS.n22 VSS.n20 18.0171
R197 VSS.n126 VSS.t1 17.926
R198 VSS.n50 VSS.n49 17.8722
R199 VSS.n5 VSS.n29 16.1529
R200 VSS.n121 VSS.t25 15.0889
R201 VSS.n89 VSS.t13 14.4208
R202 VSS.t25 VSS.n4 3.86237
R203 VSS.t5 VSS.n1 7.09036
R204 VSS.n5 VSS.n57 16.0513
R205 VSS.n118 VSS.n3 5.19805
R206 VSS.n117 VSS.t40 11.2645
R207 VSS.n117 VSS.t45 11.2645
R208 VSS.n50 VSS.n41 11.0626
R209 VSS.n4 VSS.t5 14.6144
R210 VSS.n0 VSS.t17 15.2243
R211 VSS.n0 VSS 1.90182
R212 VSS.n8 VSS.t43 13.7184
R213 VSS.n119 VSS.n118 9.78302
R214 VSS.n9 VSS.n116 13.3889
R215 VSS.n39 VSS.t7 9.55388
R216 VSS.n127 VSS.n11 9.5505
R217 VSS.n10 VSS 3.0483
R218 VSS VSS.n115 9.3005
R219 VSS.n116 VSS 9.3005
R220 VSS.n9 VSS 2.84831
R221 VSS.n8 VSS 2.84831
R222 VSS VSS.n117 9.3005
R223 VSS VSS.n119 9.3005
R224 VSS.n120 VSS 9.3005
R225 VSS.n7 VSS 3.0483
R226 VSS VSS.n6 2.84831
R227 VSS VSS.n4 2.84831
R228 VSS.n127 VSS.n126 9.3005
R229 VSS.n40 VSS.n39 9.22616
R230 VSS.t35 VSS.n6 12.5664
R231 VSS.n39 VSS.n22 8.79144
R232 VSS.n104 VSS.n89 8.38942
R233 VSS.n72 VSS.n71 8.3038
R234 VSS.n45 VSS.n38 8.23702
R235 VSS.n95 VSS.n12 6.22327
R236 VSS.n103 VSS.n102 6.22327
R237 VSS.n104 VSS.n103 6.22327
R238 VSS.n102 VSS.n11 5.1205
R239 VSS.n120 VSS.t37 5.0968
R240 VSS.n115 VSS.t22 5.0968
R241 VSS.t48 VSS.n120 4.08939
R242 VSS.n115 VSS.t47 4.08939
R243 VSS.n89 VSS.n79 4.05712
R244 VSS.n2 VSS.t7 4.03175
R245 VSS.n2 VSS.n127 3.97967
R246 VSS.n41 VSS.n40 3.58653
R247 VSS.n1 VSS.t19 5.52557
R248 VSS.n60 VSS.n59 3.28531
R249 VSS.n41 VSS.t7 3.11691
R250 VSS.n121 VSS 2.99949
R251 VSS.n7 VSS.t35 6.0224
R252 VSS.t13 VSS.n80 2.51189
R253 VSS.t1 VSS.n125 2.51189
R254 VSS.n9 VSS.t43 5.27037
R255 VSS.n0 VSS.t32 3.43303
R256 VSS.n95 VSS.n11 1.10327
R257 VSS.t38 VSS.t48 1.00791
R258 VSS.t47 VSS.t23 1.00791
R259 VSS.n38 VSS.n34 0.890935
R260 VSS.n71 VSS.n21 0.824152
R261 VSS.t17 VSS.n6 4.37437
R262 VSS.n126 VSS.n12 0.551885
R263 VSS.t40 VSS.n3 5.70926
R264 VSS.t45 VSS.n8 4.11837
R265 VSS.n7 VSS.t38 3.56196
R266 VSS.n119 VSS.t37 0.356056
R267 VSS.n116 VSS.t23 0.356056
R268 VSS.t22 VSS.n10 3.56196
R269 VSS.n3 VSS 1.88304
R270 VSS.n1 VSS 1.5184
R271 VSS VSS.n2 1.09461
R272 x4.Y.n2 x4.Y.t15 1043.42
R273 x4.Y.n3 x4.Y.t16 1043.42
R274 x4.Y.n2 x4.Y.t13 1043.25
R275 x4.Y.n3 x4.Y.t18 1043.25
R276 x4.Y.n1 x4.Y.t12 1038.91
R277 x4.Y.n0 x4.Y.t19 1038.91
R278 x4.Y.n1 x4.Y.t14 1038.54
R279 x4.Y.n0 x4.Y.t17 1038.54
R280 x4.Y.n15 x4.Y.n10 312.226
R281 x4.Y.n14 x4.Y.n11 312.226
R282 x4.Y.n13 x4.Y.n12 311.849
R283 x4.Y.n5 x4.Y.t10 214.587
R284 x4.Y.n5 x4.Y.t11 214.587
R285 x4.Y.n17 x4.Y.n8 203.322
R286 x4.Y.n16 x4.Y.n9 202.97
R287 x4.Y.n16 x4.Y.n15 137.036
R288 x4.Y.n18 x4.Y.n17 51.9534
R289 x4.Y.n15 x4.Y.n14 45.5534
R290 x4.Y.n14 x4.Y.n13 45.177
R291 x4.Y.n17 x4.Y.n16 45.177
R292 x4.Y.n9 x4.Y.t0 40.0005
R293 x4.Y.n9 x4.Y.t1 40.0005
R294 x4.Y.n8 x4.Y.t2 40.0005
R295 x4.Y.n8 x4.Y.t3 40.0005
R296 x4.Y.n12 x4.Y.t8 27.5805
R297 x4.Y.n12 x4.Y.t9 27.5805
R298 x4.Y.n11 x4.Y.t6 27.5805
R299 x4.Y.n11 x4.Y.t7 27.5805
R300 x4.Y.n10 x4.Y.t4 27.5805
R301 x4.Y.n10 x4.Y.t5 27.5805
R302 x4.Y.n13 x4.Y 23.4672
R303 x4.Y.n7 x4.Y 21.2555
R304 x4.Y x4.Y.n18 12.5872
R305 x4.Y x4.Y.n7 10.8805
R306 x4.Y x4.Y.n6 8.84568
R307 x4.Y.n6 x4.Y.n5 8.22323
R308 x4.Y.n6 x4.Y.n4 7.91176
R309 x4.Y.n1 x4.Y.n2 5.898
R310 x4.Y.n0 x4.Y.n3 5.898
R311 x4.Y x4.Y.n7 3.62717
R312 x4.Y.n18 x4.Y 1.9205
R313 x4.Y.n4 x4.Y.n0 1.19112
R314 x4.Y.n4 x4.Y.n1 1.17863
C0 VDD a_932_2929# 0.73596f
C1 VDD a_1561_2214# 0.558f
C2 a_366_n1852# VDD 1.86014f
C3 a_929_2214# a_1561_2214# 0.17079f
C4 CLK COMP_OUT 0.20424f
C5 x3.D x4.Y 1.12148f
C6 VDD COMP_OUT 0.70164f
C7 x2.VLAT_PLUS a_366_n1852# 0.55818f
C8 x2.VLAT_PLUS VDD 3.61778f
C9 x2.VLAT_PLUS a_929_2214# 0.22271f
C10 x3.D a_1561_2214# 0.21045f
C11 x3.D VDD 1.76503f
C12 a_624_n1852# VINN 0.65468f
C13 a_1570_n570# VINN 0.7501f
C14 x4.Y x2.VLAT_MINUS 1.13437f
C15 VDD a_504_4961# 0.94182f
C16 a_624_n1852# x2.VLAT_MINUS 0.13604f
C17 a_1570_n570# x2.VLAT_MINUS 0.83615f
C18 a_624_n1852# x4.Y 0.74231f
C19 a_881_2436# a_932_2929# 0.3501f
C20 CLK x4.Y 0.76471f
C21 a_1570_n570# x4.Y 0.60943f
C22 x2.VLAT_MINUS a_1561_2214# 0.33021f
C23 a_366_n1852# x4.Y 0.75336f
C24 a_881_2436# VDD 0.4971f
C25 VINP a_624_n1852# 0.65494f
C26 VDD x2.VLAT_MINUS 3.16612f
C27 VDD x4.Y 9.49622f
C28 a_881_2436# a_929_2214# 0.34901f
C29 a_1570_n570# a_624_n1852# 1.07677f
C30 a_366_n1852# VINP 0.75123f
C31 a_932_2929# a_1561_2214# 0.17077f
C32 a_366_n1852# a_624_n1852# 1.15167f
C33 x2.VLAT_PLUS a_881_2436# 0.31507f
C34 a_929_4961# VDD 0.80031f
C35 x2.VLAT_PLUS x2.VLAT_MINUS 0.98453f
C36 x2.VLAT_PLUS x4.Y 2.22706f
C37 VDD CLK 1.8156f
C38 a_1570_n570# VDD 1.86792f
C39 COMP_OUT VSS 1.14444f
C40 a_624_n1852# VSS 5.10535f
C41 a_1570_n570# VSS 3.24124f
C42 a_366_n1852# VSS 3.08542f
C43 a_929_2214# VSS 4.10328f
C44 a_1055_4595# VSS 3.61667f
C45 x4.Y VSS 13.0508f
C46 a_630_4595# VSS 0.64817f
C47 a_1013_4961# VSS 0.79639f
C48 a_929_4961# VSS 4.40717f
C49 x4.Y.n0 VSS 0.42775f
C50 x4.Y.n1 VSS 0.42638f
C51 x4.Y.n2 VSS 0.8259f
C52 x4.Y.n3 VSS 0.8259f
C53 x4.Y.n4 VSS 0.21588f
C54 x4.Y.n5 VSS 0.58317f
C55 x4.Y.n6 VSS 1.25738f
C56 x4.Y.n7 VSS 2.5567f
C57 x4.Y.t4 VSS 0.99152f
C58 VSS.t7 VSS 0.79187f
C59 VSS.t25 VSS 1.04731f
C60 VSS.t19 VSS 7.22224f
C61 VSS.t23 VSS 0.2128f
C62 VSS.t13 VSS 1.53628f
C63 VSS.t22 VSS 0.2128f
C64 VSS.t17 VSS 0.48974f
C65 VSS.t5 VSS 1.22416f
C66 VSS.t1 VSS 0.27691f
.ends
