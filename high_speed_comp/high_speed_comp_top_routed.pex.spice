* NGSPICE file created from high_speed_comp_top_routed.ext - technology: sky130A

.subckt high_speed_comp_top_routed VINP VINN VDD VSS CLK COMP_OUT
X0 a_504_4961# a_231_4595# a_419_4595# VDD.t2 sky130_fd_pr__pfet_01v8_hvt ad=0.06825 pd=0.745 as=0.05775 ps=0.695 w=0.42 l=0.15
X1 VDD.t29 a_672_4707# a_599_4961# VDD.t28 sky130_fd_pr__pfet_01v8_hvt ad=0.17887 pd=1.26 as=0.07665 ps=0.785 w=0.42 l=0.15
X2 a_929_2214# a_881_2436# VSS.t7 VSS.t6 sky130_fd_pr__nfet_01v8 ad=0.29 pd=2.58 as=0.29 ps=2.58 w=1 l=0.15
X3 a_929_4961# a_65_4595.t4 a_672_4707# VDD.t30 sky130_fd_pr__pfet_01v8_hvt ad=0.0567 pd=0.69 as=0.1095 ps=1.075 w=0.42 l=0.15
X4 VDD.t17 a_1097_4863# a_1013_4961# VDD.t16 sky130_fd_pr__pfet_01v8_hvt ad=0.1113 pd=1.37 as=0.0882 ps=0.84 w=0.42 l=0.15
X5 a_929_4961# a_231_4595# a_672_4707# VSS.t3 sky130_fd_pr__special_nfet_01v8 ad=0.0684 pd=0.74 as=0.0989 ps=0.995 w=0.36 l=0.15
X6 x3.D a_1561_2214# VDD.t34 VDD.t33 sky130_fd_pr__pfet_01v8 ad=0.29 pd=2.58 as=0.29 ps=2.58 w=1 l=0.15
X7 x2.VLAT_PLUS x4.Y.t17 VDD.t14 VDD.t13 sky130_fd_pr__pfet_01v8 ad=0.825 pd=5.33 as=1.55 ps=10.62 w=5 l=0.15
X8 a_231_4595# a_65_4595.t5 VSS.t21 VSS.t20 sky130_fd_pr__nfet_01v8 ad=0.1092 pd=1.36 as=0.0567 ps=0.69 w=0.42 l=0.15
X9 a_1561_2214# x2.VLAT_MINUS a_929_2214# VSS.t28 sky130_fd_pr__nfet_01v8 ad=0.29 pd=2.58 as=0.29 ps=2.58 w=1 l=0.15
X10 COMP_OUT a_1097_4863# VDD.t19 VDD.t18 sky130_fd_pr__pfet_01v8_hvt ad=0.135 pd=1.27 as=0.135 ps=1.27 w=1 l=0.15
X11 x4.Y.t4 CLK VDD.t47 VDD.t46 sky130_fd_pr__pfet_01v8_hvt ad=0.14 pd=1.28 as=0.305 ps=2.61 w=1 l=0.15
X12 VDD.t50 CLK x4.Y.t7 VDD.t49 sky130_fd_pr__pfet_01v8_hvt ad=0.14 pd=1.28 as=0.14 ps=1.28 w=1 l=0.15
X13 COMP_OUT a_1097_4863# VSS.t15 VSS.t14 sky130_fd_pr__nfet_01v8 ad=0.08775 pd=0.92 as=0.08775 ps=0.92 w=0.65 l=0.15
X14 VDD.t41 CLK a_65_4595.t1 VDD.t48 sky130_fd_pr__pfet_01v8_hvt ad=0.0864 pd=0.91 as=0.1664 ps=1.8 w=0.64 l=0.15
X15 x4.Y.t8 CLK VDD.t50 VDD.t54 sky130_fd_pr__pfet_01v8_hvt ad=0.14 pd=1.28 as=0.14 ps=1.28 w=1 l=0.15
X16 VSS.t35 VDD.t58 VSS.t34 VSS.t33 sky130_fd_pr__nfet_01v8 ad=0.143 pd=1.62 as=0 ps=0 w=0.55 l=0.59
X17 x2.VLAT_MINUS x4.Y.t15 VDD.t27 VDD.t26 sky130_fd_pr__pfet_01v8 ad=0.825 pd=5.33 as=1.55 ps=10.62 w=5 l=0.15
X18 VDD.t5 x4.Y.t14 x2.VLAT_MINUS VDD.t4 sky130_fd_pr__pfet_01v8 ad=1.55 pd=10.62 as=0.825 ps=5.33 w=5 l=0.15
X19 VDD.t52 CLK x4.Y.t5 VDD.t51 sky130_fd_pr__pfet_01v8_hvt ad=0.14 pd=1.28 as=0.14 ps=1.28 w=1 l=0.15
X20 a_932_2929# a_881_2436# VDD.t10 VDD.t9 sky130_fd_pr__pfet_01v8 ad=0.29 pd=2.58 as=0.29 ps=2.58 w=1 l=0.15
X21 a_1570_n470# x4.Y.t13 VDD.t5 VDD.t22 sky130_fd_pr__pfet_01v8 ad=0.825 pd=5.33 as=1.55 ps=10.62 w=5 l=0.15
X22 VDD.t19 a_929_4961# a_1097_4863# VDD.t39 sky130_fd_pr__pfet_01v8_hvt ad=0.135 pd=1.27 as=0.27 ps=2.54 w=1 l=0.15
X23 VDD.t43 x4.Y.t12 a_1570_n470# VDD.t42 sky130_fd_pr__pfet_01v8 ad=1.55 pd=10.62 as=0.825 ps=5.33 w=5 l=0.15
X24 VDD.t56 CLK x4.Y.t9 VDD.t55 sky130_fd_pr__pfet_01v8_hvt ad=0.345 pd=2.69 as=0.14 ps=1.28 w=1 l=0.15
X25 VSS.t15 a_929_4961# a_1097_4863# VSS.t31 sky130_fd_pr__nfet_01v8 ad=0.08775 pd=0.92 as=0.169 ps=1.82 w=0.65 l=0.15
X26 VSS.t38 VDD.t57 VSS.t37 VSS.t36 sky130_fd_pr__nfet_01v8 ad=0.143 pd=1.62 as=0 ps=0 w=0.55 l=0.59
X27 a_504_4961# a_65_4595.t3 a_419_4595# VSS.t4 sky130_fd_pr__special_nfet_01v8 ad=0.0621 pd=0.705 as=0.0813 ps=0.83 w=0.36 l=0.15
X28 VSS.t19 a_672_4707# a_630_4595# VSS.t18 sky130_fd_pr__nfet_01v8 ad=0.12095 pd=1.085 as=0.0696 ps=0.765 w=0.42 l=0.15
X29 x4.Y.t6 CLK VDD.t52 VDD.t53 sky130_fd_pr__pfet_01v8_hvt ad=0.14 pd=1.28 as=0.14 ps=1.28 w=1 l=0.15
X30 a_1561_2214# x2.VLAT_MINUS a_932_2929# VDD.t35 sky130_fd_pr__pfet_01v8 ad=0.29 pd=2.58 as=0.29 ps=2.58 w=1 l=0.15
X31 VSS.t11 x4.Y.t11 a_624_n1752# VSS.t30 sky130_fd_pr__nfet_01v8_lvt ad=0.725 pd=5.29 as=1.45 ps=10.58 w=5 l=1
X32 a_419_4595# x3.D VSS.t1 VSS.t0 sky130_fd_pr__nfet_01v8 ad=0.0813 pd=0.83 as=0.1092 ps=1.36 w=0.42 l=0.15
X33 a_630_4595# a_231_4595# a_504_4961# VSS.t2 sky130_fd_pr__special_nfet_01v8 ad=0.0696 pd=0.765 as=0.0621 ps=0.705 w=0.36 l=0.15
X34 a_929_2214# x2.VLAT_PLUS a_881_2436# VSS.t22 sky130_fd_pr__nfet_01v8 ad=0.29 pd=2.58 as=0.29 ps=2.58 w=1 l=0.15
X35 x2.VLAT_PLUS x2.VLAT_MINUS VDD.t37 VDD.t36 sky130_fd_pr__pfet_01v8 ad=0.29 pd=2.58 as=0.29 ps=2.58 w=1 l=0.15
X36 VDD.t8 VSS.t48 VDD.t7 VDD.t6 sky130_fd_pr__pfet_01v8_hvt ad=0.2262 pd=2.26 as=0 ps=0 w=0.87 l=0.59
X37 a_624_n1752# VINN a_1570_n470# VSS.t24 sky130_fd_pr__nfet_01v8_lvt ad=0.725 pd=5.29 as=1.45 ps=10.58 w=5 l=1
X38 VSS.t21 CLK a_65_4595.t0 VSS.t41 sky130_fd_pr__nfet_01v8 ad=0.0567 pd=0.69 as=0.1092 ps=1.36 w=0.42 l=0.15
X39 VDD.t21 a_1097_4863# COMP_OUT VDD.t20 sky130_fd_pr__pfet_01v8_hvt ad=0.26 pd=2.52 as=0.135 ps=1.27 w=1 l=0.15
X40 VSS.t17 a_1097_4863# COMP_OUT VSS.t16 sky130_fd_pr__nfet_01v8 ad=0.169 pd=1.82 as=0.08775 ps=0.92 w=0.65 l=0.15
X41 a_366_n1752# x4.Y.t19 VDD.t12 VDD.t11 sky130_fd_pr__pfet_01v8 ad=0.825 pd=5.33 as=1.55 ps=10.62 w=5 l=0.15
X42 x2.VLAT_PLUS x2.VLAT_MINUS a_366_n1752# VSS.t29 sky130_fd_pr__nfet_01v8 ad=0.29 pd=2.58 as=0.29 ps=2.58 w=1 l=0.15
X43 a_672_4707# a_504_4961# VSS.t19 VSS.t32 sky130_fd_pr__nfet_01v8 ad=0.0989 pd=0.995 as=0.12095 ps=1.085 w=0.64 l=0.15
X44 a_1055_4595# a_65_4595.t2 a_929_4961# VSS.t5 sky130_fd_pr__special_nfet_01v8 ad=0.066 pd=0.745 as=0.0684 ps=0.74 w=0.36 l=0.15
X45 VSS.t13 a_1097_4863# a_1055_4595# VSS.t12 sky130_fd_pr__nfet_01v8 ad=0.1092 pd=1.36 as=0.066 ps=0.745 w=0.42 l=0.15
X46 x3.D a_1561_2214# VSS.t27 VSS.t26 sky130_fd_pr__nfet_01v8 ad=0.29 pd=2.58 as=0.29 ps=2.58 w=1 l=0.15
X47 VDD.t14 x4.Y.t18 a_366_n1752# VDD.t15 sky130_fd_pr__pfet_01v8 ad=1.55 pd=10.62 as=0.825 ps=5.33 w=5 l=0.15
X48 VDD.t25 VSS.t47 VDD.t24 VDD.t23 sky130_fd_pr__pfet_01v8_hvt ad=0.2262 pd=2.26 as=0 ps=0 w=0.87 l=0.59
X49 a_1570_n470# VINN a_624_n1752# VSS.t25 sky130_fd_pr__nfet_01v8_lvt ad=1.45 pd=10.58 as=0.725 ps=5.29 w=5 l=1
X50 a_419_4595# x3.D VDD.t1 VDD.t0 sky130_fd_pr__pfet_01v8_hvt ad=0.05775 pd=0.695 as=0.1092 ps=1.36 w=0.42 l=0.15
X51 a_1013_4961# a_231_4595# a_929_4961# VDD.t3 sky130_fd_pr__pfet_01v8_hvt ad=0.0882 pd=0.84 as=0.0567 ps=0.69 w=0.42 l=0.15
X52 a_599_4961# a_65_4595.t6 a_504_4961# VDD.t38 sky130_fd_pr__pfet_01v8_hvt ad=0.07665 pd=0.785 as=0.06825 ps=0.745 w=0.42 l=0.15
X53 a_932_2929# x2.VLAT_PLUS a_881_2436# VDD.t31 sky130_fd_pr__pfet_01v8 ad=0.29 pd=2.58 as=0.29 ps=2.58 w=1 l=0.15
X54 a_624_n1752# x4.Y.t10 VSS.t11 VSS.t10 sky130_fd_pr__nfet_01v8_lvt ad=1.45 pd=10.58 as=0.725 ps=5.29 w=5 l=1
X55 x4.Y.t2 CLK VSS.t43 VSS.t44 sky130_fd_pr__nfet_01v8 ad=0.0588 pd=0.7 as=0.0588 ps=0.7 w=0.42 l=0.15
X56 VDD.t27 x2.VLAT_PLUS x2.VLAT_MINUS VDD.t32 sky130_fd_pr__pfet_01v8 ad=0.29 pd=2.58 as=0.29 ps=2.58 w=1 l=0.15
X57 a_672_4707# a_504_4961# VDD.t29 VDD.t45 sky130_fd_pr__pfet_01v8_hvt ad=0.1095 pd=1.075 as=0.17887 ps=1.26 w=0.75 l=0.15
X58 VSS.t46 CLK x4.Y.t3 VSS.t45 sky130_fd_pr__nfet_01v8 ad=0.1659 pd=1.63 as=0.0588 ps=0.7 w=0.42 l=0.15
X59 a_1570_n470# x2.VLAT_PLUS x2.VLAT_MINUS VSS.t23 sky130_fd_pr__nfet_01v8 ad=0.29 pd=2.58 as=0.29 ps=2.58 w=1 l=0.15
X60 a_231_4595# a_65_4595.t7 VDD.t41 VDD.t40 sky130_fd_pr__pfet_01v8_hvt ad=0.1664 pd=1.8 as=0.0864 ps=0.91 w=0.64 l=0.15
X61 x4.Y.t0 CLK VSS.t40 VSS.t39 sky130_fd_pr__nfet_01v8 ad=0.0588 pd=0.7 as=0.1386 ps=1.5 w=0.42 l=0.15
X62 VDD.t37 x4.Y.t16 x2.VLAT_PLUS VDD.t44 sky130_fd_pr__pfet_01v8 ad=1.55 pd=10.62 as=0.825 ps=5.33 w=5 l=0.15
X63 a_366_n1752# VINP a_624_n1752# VSS.t9 sky130_fd_pr__nfet_01v8_lvt ad=1.45 pd=10.58 as=0.725 ps=5.29 w=5 l=1
X64 a_624_n1752# VINP a_366_n1752# VSS.t8 sky130_fd_pr__nfet_01v8_lvt ad=0.725 pd=5.29 as=1.45 ps=10.58 w=5 l=1
X65 VSS.t43 CLK x4.Y.t1 VSS.t42 sky130_fd_pr__nfet_01v8 ad=0.0588 pd=0.7 as=0.0588 ps=0.7 w=0.42 l=0.15
R0 VDD.n137 VDD.n74 3031.76
R1 VDD.n137 VDD.n73 3031.76
R2 VDD.n128 VDD.n5 3031.76
R3 VDD.n100 VDD.n97 3031.76
R4 VDD.n105 VDD.n97 3031.76
R5 VDD.n110 VDD.n82 3031.76
R6 VDD.n134 VDD.n76 2290.59
R7 VDD.n134 VDD.n75 2290.59
R8 VDD.n102 VDD.n93 2290.59
R9 VDD.n102 VDD.n94 2290.59
R10 VDD.n83 VDD.n79 1510.59
R11 VDD.n90 VDD.n85 1510.59
R12 VDD.n68 VDD.n24 1312.94
R13 VDD.n50 VDD.n44 1312.94
R14 VDD.n130 VDD.n79 1238.82
R15 VDD.n112 VDD.n90 1238.82
R16 VDD.n17 VDD.t23 760.918
R17 VDD.n91 VDD.n88 755.294
R18 VDD.n88 VDD.n86 755.294
R19 VDD.n27 VDD.n26 755.294
R20 VDD.n27 VDD.n23 755.294
R21 VDD.n41 VDD.n40 755.294
R22 VDD.n41 VDD.n38 755.294
R23 VDD.n35 VDD.n30 755.294
R24 VDD.n35 VDD.n32 755.294
R25 VDD.n76 VDD.n74 741.178
R26 VDD.n130 VDD.n76 741.178
R27 VDD.n75 VDD.n73 741.178
R28 VDD.n128 VDD.n75 741.178
R29 VDD.n112 VDD.n93 741.178
R30 VDD.n100 VDD.n93 741.178
R31 VDD.n110 VDD.n94 741.178
R32 VDD.n105 VDD.n94 741.178
R33 VDD.t6 VDD.t20 739.875
R34 VDD.t23 VDD.t55 736.917
R35 VDD.n7 VDD.t48 632.625
R36 VDD.t39 VDD.t16 621.495
R37 VDD.n84 VDD.n83 557.648
R38 VDD.n86 VDD.n84 557.648
R39 VDD.n124 VDD.n86 557.648
R40 VDD.n124 VDD.n85 557.648
R41 VDD.n89 VDD.n79 557.648
R42 VDD.n91 VDD.n89 557.648
R43 VDD.n119 VDD.n91 557.648
R44 VDD.n119 VDD.n90 557.648
R45 VDD.n66 VDD.n26 557.648
R46 VDD.n61 VDD.n26 557.648
R47 VDD.n61 VDD.n30 557.648
R48 VDD.n54 VDD.n30 557.648
R49 VDD.n54 VDD.n40 557.648
R50 VDD.n50 VDD.n40 557.648
R51 VDD.n68 VDD.n23 557.648
R52 VDD.n60 VDD.n23 557.648
R53 VDD.n60 VDD.n32 557.648
R54 VDD.n55 VDD.n32 557.648
R55 VDD.n55 VDD.n38 557.648
R56 VDD.n48 VDD.n38 557.648
R57 VDD.t0 VDD.t40 556.386
R58 VDD.n16 VDD.t6 544.548
R59 VDD.n6 VDD.n8 528.84
R60 VDD.n114 VDD.n6 528.84
R61 VDD.t46 VDD.n16 440.966
R62 VDD.t45 VDD.t28 390.654
R63 VDD.t32 VDD.n120 352.187
R64 VDD.n123 VDD.t36 352.187
R65 VDD.t16 VDD.t3 337.384
R66 VDD.n99 VDD.n98 323.526
R67 VDD.n138 VDD.n72 323.389
R68 VDD.t28 VDD.t38 304.829
R69 VDD.t38 VDD.t2 281.154
R70 VDD.t30 VDD.t45 281.154
R71 VDD.t9 VDD.n25 264.262
R72 VDD.t31 VDD.n25 264.262
R73 VDD.t31 VDD.n31 264.262
R74 VDD.t35 VDD.n31 264.262
R75 VDD.t35 VDD.n39 264.262
R76 VDD.t33 VDD.n39 264.262
R77 VDD.t51 VDD.t46 254.518
R78 VDD.t53 VDD.t51 254.518
R79 VDD.t49 VDD.t53 254.518
R80 VDD.t54 VDD.t49 254.518
R81 VDD.t55 VDD.t54 254.518
R82 VDD.t2 VDD.t0 251.559
R83 VDD.n98 VDD.n96 251.405
R84 VDD.n139 VDD.n138 250.345
R85 VDD.t40 VDD.t48 248.599
R86 VDD.t3 VDD.t30 248.599
R87 VDD.t18 VDD.t39 248.599
R88 VDD.t20 VDD.t18 248.599
R89 VDD.n133 VDD.n132 244.329
R90 VDD.n101 VDD.n92 244.329
R91 VDD.n133 VDD.n78 242.825
R92 VDD.n101 VDD.n95 242.825
R93 VDD.n67 VDD.n24 237.584
R94 VDD.n49 VDD.n44 237.584
R95 VDD.n20 VDD.n16 211.794
R96 VDD.n51 VDD.n43 139.976
R97 VDD.n114 VDD.n113 132.142
R98 VDD.n131 VDD.n8 132.142
R99 VDD.n65 VDD.n64 121.138
R100 VDD.n137 VDD.t11 117.906
R101 VDD.t42 VDD.n97 117.906
R102 VDD.t15 VDD.n135 107.025
R103 VDD.n135 VDD.t13 107.025
R104 VDD.n121 VDD.t44 107.025
R105 VDD.t26 VDD.n87 107.025
R106 VDD.n103 VDD.t4 107.025
R107 VDD.t22 VDD.n103 107.025
R108 VDD.n120 VDD.n89 92.5005
R109 VDD.n116 VDD.n89 92.5005
R110 VDD.n120 VDD.n119 92.5005
R111 VDD.n119 VDD.n118 92.5005
R112 VDD.n124 VDD.n123 92.5005
R113 VDD.n6 VDD.n124 92.5005
R114 VDD.n123 VDD.n84 92.5005
R115 VDD.n6 VDD.n84 92.5005
R116 VDD.n68 VDD.t9 92.5005
R117 VDD.n69 VDD.n68 92.5005
R118 VDD.t31 VDD.n60 92.5005
R119 VDD.n60 VDD.n59 92.5005
R120 VDD.n55 VDD.t35 92.5005
R121 VDD.n56 VDD.n55 92.5005
R122 VDD.n48 VDD.n47 92.5005
R123 VDD.n50 VDD.t33 92.5005
R124 VDD.n51 VDD.n50 92.5005
R125 VDD.t35 VDD.n54 92.5005
R126 VDD.n54 VDD.n53 92.5005
R127 VDD.n61 VDD.t31 92.5005
R128 VDD.n62 VDD.n61 92.5005
R129 VDD.n66 VDD.n65 92.5005
R130 VDD.n45 VDD.n43 83.2475
R131 VDD.n117 VDD.n115 80.5652
R132 VDD.n115 VDD.n6 80.5652
R133 VDD.n36 VDD.n29 80.5652
R134 VDD.n37 VDD.n36 80.5652
R135 VDD.n63 VDD.n28 80.5652
R136 VDD.n33 VDD.n28 80.5652
R137 VDD.n113 VDD.n92 79.0593
R138 VDD.n99 VDD.n92 79.0593
R139 VDD.n132 VDD.n72 79.0593
R140 VDD.n132 VDD.n131 79.0593
R141 VDD.n67 VDD.n66 70.7763
R142 VDD.n49 VDD.n48 70.7763
R143 VDD.n122 VDD.t32 65.0195
R144 VDD.t36 VDD.n122 65.0195
R145 VDD.n52 VDD.n42 61.6559
R146 VDD.n116 VDD.n8 59.4829
R147 VDD.n117 VDD.n116 59.4829
R148 VDD.n118 VDD.n117 59.4829
R149 VDD.n118 VDD.n114 59.4829
R150 VDD.n65 VDD.n63 59.4829
R151 VDD.n63 VDD.n62 59.4829
R152 VDD.n62 VDD.n29 59.4829
R153 VDD.n53 VDD.n29 59.4829
R154 VDD.n53 VDD.n52 59.4829
R155 VDD.n52 VDD.n51 59.4829
R156 VDD.n105 VDD.n104 46.2505
R157 VDD.n106 VDD.n105 46.2505
R158 VDD.n111 VDD.n110 46.2505
R159 VDD.n110 VDD.n109 46.2505
R160 VDD.n112 VDD.n111 46.2505
R161 VDD.n113 VDD.n112 46.2505
R162 VDD.n104 VDD.n100 46.2505
R163 VDD.n100 VDD.n99 46.2505
R164 VDD.n122 VDD.n88 46.2505
R165 VDD.n115 VDD.n88 46.2505
R166 VDD.n130 VDD.n129 46.2505
R167 VDD.n131 VDD.n130 46.2505
R168 VDD.n136 VDD.n74 46.2505
R169 VDD.n74 VDD.n72 46.2505
R170 VDD.n136 VDD.n73 46.2505
R171 VDD.n73 VDD.n71 46.2505
R172 VDD.n129 VDD.n128 46.2505
R173 VDD.n128 VDD.n127 46.2505
R174 VDD.n44 VDD.n43 46.2505
R175 VDD.n64 VDD.n24 46.2505
R176 VDD.n27 VDD.n25 46.2505
R177 VDD.n28 VDD.n27 46.2505
R178 VDD.n41 VDD.n39 46.2505
R179 VDD.n42 VDD.n41 46.2505
R180 VDD.n35 VDD.n31 46.2505
R181 VDD.n36 VDD.n35 46.2505
R182 VDD.n83 VDD.n5 42.3534
R183 VDD.n85 VDD.n82 42.3534
R184 VDD.n122 VDD.n121 35.0144
R185 VDD.n122 VDD.n87 35.0144
R186 VDD.t11 VDD.n136 31.7112
R187 VDD.n136 VDD.t15 31.7112
R188 VDD.n129 VDD.t13 31.7112
R189 VDD.n129 VDD.t44 31.7112
R190 VDD.n111 VDD.t26 31.7112
R191 VDD.n111 VDD.t4 31.7112
R192 VDD.n104 VDD.t22 31.7112
R193 VDD.n104 VDD.t42 31.7112
R194 VDD.n0 VDD.n1 1.67869
R195 VDD.n1 VDD.t19 26.7681
R196 VDD.t50 VDD.n14 22.8514
R197 VDD.n2 VDD.n0 2.22326
R198 VDD.n12 VDD.t52 5.0058
R199 VDD.n9 VDD.t21 22.6053
R200 VDD.t33 VDD.n49 16.7394
R201 VDD.t9 VDD.n67 16.7394
R202 VDD.n13 VDD.t52 20.2593
R203 VDD.t41 VDD.n2 19.9697
R204 VDD.t1 VDD.n2 3.54873
R205 VDD.n70 VDD.t10 14.4208
R206 VDD.t34 VDD.n34 14.4208
R207 VDD.n13 VDD.t50 4.49053
R208 VDD.n109 VDD.n95 13.8562
R209 VDD.n127 VDD.n78 13.8562
R210 VDD.n125 VDD.n6 13.5861
R211 VDD.n107 VDD.n106 13.3283
R212 VDD.t47 VDD.n12 17.6319
R213 VDD.n77 VDD.n71 13.2624
R214 VDD.n0 VDD.t29 9.11904
R215 VDD.n14 VDD.t56 3.75941
R216 VDD.n98 VDD.n97 11.0403
R217 VDD.n121 VDD.n5 10.8829
R218 VDD.n6 VDD.n5 10.8829
R219 VDD.n87 VDD.n82 10.8829
R220 VDD.n138 VDD.n137 10.8829
R221 VDD.n135 VDD.n134 10.8829
R222 VDD.n134 VDD.n133 10.8829
R223 VDD.n103 VDD.n102 10.8829
R224 VDD.n102 VDD.n101 10.8829
R225 VDD.n13 VDD.n4 2.91343
R226 VDD.n4 VDD.n12 2.67475
R227 VDD.n20 VDD.n11 3.11024
R228 VDD.n3 VDD.n70 10.5356
R229 VDD.t17 VDD.n1 3.74127
R230 VDD.t41 VDD.n7 6.12466
R231 VDD.n11 VDD.n4 3.72074
R232 VDD.n4 VDD.n14 3.10409
R233 VDD.n6 VDD.n82 11.5535
R234 VDD.n19 VDD.t56 10.1659
R235 VDD.t7 VDD.n20 10.1659
R236 VDD.n45 VDD.n3 9.5505
R237 VDD.n126 VDD.t37 9.3005
R238 VDD.n77 VDD.t14 9.3005
R239 VDD.t12 VDD.n139 9.3005
R240 VDD.n96 VDD.t43 9.3005
R241 VDD.t5 VDD.n107 9.3005
R242 VDD.n108 VDD.t27 9.3005
R243 VDD.n22 VDD.n3 9.3005
R244 VDD.n58 VDD.n3 9.3005
R245 VDD.n3 VDD.n15 9.3005
R246 VDD.n3 VDD.n57 9.3005
R247 VDD.n46 VDD.n3 9.3005
R248 VDD.n18 VDD.n4 9.3005
R249 VDD.n4 VDD.n19 9.3005
R250 VDD.t7 VDD.n4 9.3005
R251 VDD.n4 VDD.n21 9.3005
R252 VDD.n0 VDD.n10 2.39092
R253 VDD.n9 VDD.n0 2.05286
R254 VDD.n11 VDD.t47 3.04846
R255 VDD.n108 VDD.n80 7.45617
R256 VDD.n126 VDD.n80 7.39019
R257 VDD.n57 VDD.n34 6.77477
R258 VDD.n106 VDD.n96 6.33452
R259 VDD.n139 VDD.n71 6.33452
R260 VDD.t21 VDD.n10 10.6651
R261 VDD.n56 VDD.n37 5.91395
R262 VDD.n59 VDD.n15 5.53968
R263 VDD.n109 VDD.n108 5.27885
R264 VDD.n127 VDD.n126 5.21287
R265 VDD.n81 VDD.n125 4.53781
R266 VDD.n47 VDD.n45 4.34202
R267 VDD.t25 VDD.n18 4.33436
R268 VDD.n21 VDD.t8 4.33436
R269 VDD.n58 VDD.n33 3.96775
R270 VDD.n70 VDD.n69 3.85547
R271 VDD.n33 VDD.n22 3.51863
R272 VDD.n18 VDD.t57 3.47767
R273 VDD.n21 VDD.t58 3.47767
R274 VDD.t24 VDD.n17 3.42886
R275 VDD.n17 VDD.n4 3.42666
R276 VDD.n47 VDD.n46 3.14436
R277 VDD.n64 VDD.t10 2.91696
R278 VDD.n42 VDD.t34 2.91696
R279 VDD.n69 VDD.n22 2.39582
R280 VDD.n9 VDD.t19 7.24528
R281 VDD.n59 VDD.n58 1.9467
R282 VDD.n3 VDD.t12 1.29581
R283 VDD.n57 VDD.n56 1.19816
R284 VDD.t58 VDD.t7 1.15956
R285 VDD.t57 VDD.t24 0.857193
R286 VDD.n46 VDD.n34 0.711611
R287 VDD.n125 VDD.n80 0.632835
R288 VDD.n78 VDD.n77 0.594314
R289 VDD.t37 VDD.n81 0.555508
R290 VDD.t27 VDD.n81 0.555508
R291 VDD.n107 VDD.n95 0.528335
R292 VDD.t5 VDD.t43 0.466125
R293 VDD.t37 VDD.t14 0.466125
R294 VDD.t27 VDD.t5 0.466125
R295 VDD.t12 VDD.t14 0.464563
R296 VDD.n37 VDD.n15 0.374769
R297 VDD.n19 VDD.t25 0.302862
R298 VDD.t8 VDD.n10 4.82351
R299 VDD.n0 VDD.n3 2.18288
R300 VDD.n0 VDD.n4 1.54858
R301 VDD.n0 VDD.n7 1.47435
R302 VSS.n116 VSS.n57 24835.9
R303 VSS.n116 VSS.n115 6156.29
R304 VSS.n85 VSS.n57 6073.79
R305 VSS.n114 VSS.n59 5684.03
R306 VSS.n114 VSS.n58 5684.03
R307 VSS.n87 VSS.n86 5684.03
R308 VSS.n86 VSS.n82 5684.03
R309 VSS.n90 VSS.n63 3425.61
R310 VSS.n90 VSS.n66 3425.61
R311 VSS.n73 VSS.n64 3333.03
R312 VSS.n73 VSS.n67 3333.03
R313 VSS.n103 VSS.n71 2126.44
R314 VSS.n104 VSS.n71 2126.44
R315 VSS.n96 VSS.n78 2126.44
R316 VSS.n95 VSS.n78 2126.44
R317 VSS.n124 VSS.n16 2126.44
R318 VSS.n124 VSS.n15 2126.44
R319 VSS.n51 VSS.n18 2126.44
R320 VSS.n51 VSS.n17 2126.44
R321 VSS.n87 VSS.n66 2056.91
R322 VSS.n106 VSS.n66 2056.91
R323 VSS.n108 VSS.n63 2056.91
R324 VSS.n82 VSS.n63 2056.91
R325 VSS.n106 VSS.n67 2039.53
R326 VSS.n108 VSS.n64 2039.53
R327 VSS.n64 VSS.n59 2039.53
R328 VSS.n67 VSS.n58 2039.53
R329 VSS.n98 VSS.n70 1272.06
R330 VSS.n98 VSS.n76 1272.06
R331 VSS.n27 VSS.n26 1210.97
R332 VSS.n26 VSS.n22 1210.97
R333 VSS.n30 VSS.n28 1210.97
R334 VSS.n30 VSS.n23 1210.97
R335 VSS.n36 VSS.n32 1210.97
R336 VSS.n36 VSS.n34 1210.97
R337 VSS.n118 VSS.n117 1206.14
R338 VSS.n122 VSS.n121 1198.03
R339 VSS.n32 VSS.n16 915.471
R340 VSS.n41 VSS.n32 915.471
R341 VSS.n41 VSS.n28 915.471
R342 VSS.n45 VSS.n28 915.471
R343 VSS.n45 VSS.n27 915.471
R344 VSS.n27 VSS.n18 915.471
R345 VSS.n34 VSS.n15 915.471
R346 VSS.n40 VSS.n34 915.471
R347 VSS.n40 VSS.n23 915.471
R348 VSS.n46 VSS.n23 915.471
R349 VSS.n46 VSS.n22 915.471
R350 VSS.n22 VSS.n17 915.471
R351 VSS.n96 VSS.n76 816.971
R352 VSS.n103 VSS.n76 816.971
R353 VSS.n104 VSS.n70 816.971
R354 VSS.n95 VSS.n70 816.971
R355 VSS.t16 VSS.t33 712.273
R356 VSS.n117 VSS.n116 587.619
R357 VSS.t12 VSS.t31 542.821
R358 VSS.n123 VSS.t6 538.082
R359 VSS.n33 VSS.t6 538.082
R360 VSS.t22 VSS.n33 538.082
R361 VSS.t22 VSS.n25 538.082
R362 VSS.t28 VSS.n25 538.082
R363 VSS.t28 VSS.n24 538.082
R364 VSS.n24 VSS.t26 538.082
R365 VSS.n52 VSS.t26 538.082
R366 VSS.t33 VSS.n122 528.46
R367 VSS.n122 VSS.n53 436.555
R368 VSS.t36 VSS.t45 434.553
R369 VSS.n57 VSS.n56 406.014
R370 VSS.n115 VSS.t8 399.104
R371 VSS.n74 VSS.t9 399.104
R372 VSS.n89 VSS.t24 399.104
R373 VSS.n85 VSS.t25 399.104
R374 VSS.t18 VSS.t32 364.752
R375 VSS.t3 VSS.t5 304.44
R376 VSS.t29 VSS.n103 292.5
R377 VSS.n103 VSS.n102 292.5
R378 VSS.n96 VSS.t23 292.5
R379 VSS.n97 VSS.n96 292.5
R380 VSS.t23 VSS.n95 292.5
R381 VSS.n95 VSS.n94 292.5
R382 VSS.n104 VSS.t29 292.5
R383 VSS.n105 VSS.n104 292.5
R384 VSS.t6 VSS.n15 292.5
R385 VSS.n15 VSS.n14 292.5
R386 VSS.t22 VSS.n40 292.5
R387 VSS.n40 VSS.n39 292.5
R388 VSS.n46 VSS.t28 292.5
R389 VSS.n47 VSS.n46 292.5
R390 VSS.n17 VSS.t26 292.5
R391 VSS.n49 VSS.n17 292.5
R392 VSS.n18 VSS.t26 292.5
R393 VSS.n19 VSS.n18 292.5
R394 VSS.t28 VSS.n45 292.5
R395 VSS.n45 VSS.n44 292.5
R396 VSS.n41 VSS.t22 292.5
R397 VSS.n42 VSS.n41 292.5
R398 VSS.t6 VSS.n16 292.5
R399 VSS.n16 VSS.n13 292.5
R400 VSS.t32 VSS.t3 290.079
R401 VSS.t5 VSS.t12 272.846
R402 VSS.t29 VSS.n75 259.5
R403 VSS.t23 VSS.n79 259.5
R404 VSS.n84 VSS.n83 249.637
R405 VSS.n113 VSS.n112 248.454
R406 VSS.t20 VSS.t0 243.869
R407 VSS.t31 VSS.t14 241.254
R408 VSS.t14 VSS.t16 241.254
R409 VSS.n56 VSS.t36 238.679
R410 VSS.n84 VSS.n80 237.898
R411 VSS.n113 VSS.n60 237.736
R412 VSS.n91 VSS.n81 216.534
R413 VSS.n92 VSS.n91 216.534
R414 VSS.n72 VSS.t8 211.87
R415 VSS.t9 VSS.n72 211.87
R416 VSS.n107 VSS.t30 211.87
R417 VSS.t24 VSS.n88 211.87
R418 VSS.n88 VSS.t25 211.87
R419 VSS.n111 VSS.n61 210.681
R420 VSS.n68 VSS.n61 210.681
R421 VSS.t10 VSS.n65 208.585
R422 VSS.n53 VSS.n52 190.713
R423 VSS.n117 VSS.t41 180.308
R424 VSS.n123 VSS.t18 170.28
R425 VSS.n79 VSS.n78 146.25
R426 VSS.n78 VSS.n77 146.25
R427 VSS.n75 VSS.n71 146.25
R428 VSS.n101 VSS.n71 146.25
R429 VSS.n98 VSS.n65 146.25
R430 VSS.n99 VSS.n98 146.25
R431 VSS.n52 VSS.n51 146.25
R432 VSS.n51 VSS.n50 146.25
R433 VSS.n124 VSS.n123 146.25
R434 VSS.n125 VSS.n124 146.25
R435 VSS.n36 VSS.n33 146.25
R436 VSS.n37 VSS.n36 146.25
R437 VSS.n30 VSS.n25 146.25
R438 VSS.n31 VSS.n30 146.25
R439 VSS.n26 VSS.n24 146.25
R440 VSS.n26 VSS.n20 146.25
R441 VSS.t0 VSS.t4 145.284
R442 VSS.n50 VSS.n49 138.183
R443 VSS.n102 VSS.n101 138.166
R444 VSS.n97 VSS.n77 138.166
R445 VSS.t4 VSS.t2 128.421
R446 VSS.t18 VSS.t2 118.043
R447 VSS.n125 VSS.n14 117.778
R448 VSS.t42 VSS.t39 111.558
R449 VSS.t44 VSS.t42 111.558
R450 VSS.t45 VSS.t44 111.558
R451 VSS.t41 VSS.t20 108.963
R452 VSS.t39 VSS.n53 107.665
R453 VSS.n105 VSS.n69 98.6537
R454 VSS.n94 VSS.n93 98.6537
R455 VSS.n75 VSS.n74 90.3327
R456 VSS.n89 VSS.n79 90.3327
R457 VSS.n50 VSS.n19 85.5375
R458 VSS.n100 VSS.n99 82.6519
R459 VSS.n43 VSS.n31 78.6829
R460 VSS.n31 VSS.n21 78.6829
R461 VSS.n37 VSS.n35 78.6829
R462 VSS.n38 VSS.n37 78.6829
R463 VSS.n99 VSS.n3 76.4348
R464 VSS.n72 VSS.n58 65.0005
R465 VSS.n60 VSS.n58 65.0005
R466 VSS.n107 VSS.n106 65.0005
R467 VSS.n106 VSS.n3 65.0005
R468 VSS.n88 VSS.n87 65.0005
R469 VSS.n87 VSS.n80 65.0005
R470 VSS.n88 VSS.n82 65.0005
R471 VSS.n83 VSS.n82 65.0005
R472 VSS.n108 VSS.n107 65.0005
R473 VSS.n109 VSS.n108 65.0005
R474 VSS.n72 VSS.n59 65.0005
R475 VSS.n112 VSS.n59 65.0005
R476 VSS.n38 VSS.n14 59.4829
R477 VSS.n39 VSS.n38 59.4829
R478 VSS.n39 VSS.n21 59.4829
R479 VSS.n47 VSS.n21 59.4829
R480 VSS.n48 VSS.n47 59.4829
R481 VSS.n49 VSS.n48 59.4829
R482 VSS.n48 VSS.n20 58.2963
R483 VSS.n100 VSS.n97 53.0829
R484 VSS.n102 VSS.n100 53.0829
R485 VSS.t23 VSS.t10 52.5574
R486 VSS.t29 VSS.t30 44.3454
R487 VSS.n86 VSS.n85 36.563
R488 VSS.n86 VSS.n84 36.563
R489 VSS.n115 VSS.n114 36.563
R490 VSS.n114 VSS.n113 36.563
R491 VSS.n74 VSS.n73 36.563
R492 VSS.n73 VSS.n61 36.563
R493 VSS.n90 VSS.n89 36.563
R494 VSS.n91 VSS.n90 36.563
R495 VSS VSS.n1 2.00196
R496 VSS.n2 VSS.t19 4.68362
R497 VSS.t1 VSS.n1 4.73789
R498 VSS.t15 VSS.n4 27.2133
R499 VSS.n2 VSS.t13 27.9435
R500 VSS.n54 VSS.n10 22.7698
R501 VSS.n101 VSS.n69 18.0711
R502 VSS.n93 VSS.n77 18.0711
R503 VSS.n83 VSS.n81 18.0171
R504 VSS.n126 VSS.t7 17.926
R505 VSS.n5 VSS.t17 23.1173
R506 VSS.n112 VSS.n111 17.8722
R507 VSS.t40 VSS.n7 21.4447
R508 VSS.n94 VSS.n3 16.1529
R509 VSS.t43 VSS.n8 19.9748
R510 VSS.n1 VSS.t21 20.7484
R511 VSS.n29 VSS.t27 14.4208
R512 VSS.n9 VSS.t46 17.0779
R513 VSS.n111 VSS.n110 11.0626
R514 VSS.n121 VSS.n120 10.648
R515 VSS.n56 VSS.n11 1203.55
R516 VSS.n3 VSS.n105 16.0513
R517 VSS.n62 VSS.t11 9.55388
R518 VSS.n127 VSS.n12 9.5505
R519 VSS.t43 VSS.n9 4.65384
R520 VSS.n11 VSS 3.00917
R521 VSS.n121 VSS.n7 4.39458
R522 VSS.n8 VSS.t40 4.19847
R523 VSS.n10 VSS.t46 4.80605
R524 VSS VSS.n55 9.3005
R525 VSS.n54 VSS 9.3005
R526 VSS.n10 VSS 2.32845
R527 VSS VSS.n9 2.4157
R528 VSS.n8 VSS 2.63007
R529 VSS VSS.n7 2.5345
R530 VSS.n120 VSS 9.3005
R531 VSS VSS.n119 9.3005
R532 VSS.n6 VSS 2.35951
R533 VSS VSS.n5 2.05286
R534 VSS.n4 VSS 2.05286
R535 VSS.n127 VSS.n126 9.3005
R536 VSS.n109 VSS.n62 9.22616
R537 VSS.n81 VSS.n62 8.79144
R538 VSS.n44 VSS.n29 8.38942
R539 VSS.n92 VSS.n80 8.3038
R540 VSS.n68 VSS.n60 8.23702
R541 VSS.n35 VSS.n13 6.22327
R542 VSS.n43 VSS.n42 6.22327
R543 VSS.n44 VSS.n43 6.22327
R544 VSS.t21 VSS.n118 5.76484
R545 VSS.n119 VSS.t34 5.76385
R546 VSS.n55 VSS.t37 5.76385
R547 VSS.n6 VSS.t17 10.216
R548 VSS.n42 VSS.n12 5.1205
R549 VSS.n119 VSS.t48 4.62458
R550 VSS.n55 VSS.t47 4.62458
R551 VSS.n29 VSS.n19 4.05712
R552 VSS.n0 VSS.t11 4.01612
R553 VSS.n0 VSS.n127 3.97967
R554 VSS.n110 VSS.n109 3.58653
R555 VSS.n107 VSS.n65 3.28531
R556 VSS.n110 VSS.t11 3.11691
R557 VSS.t13 VSS.n4 8.26928
R558 VSS.t27 VSS.n20 2.51189
R559 VSS.t7 VSS.n125 2.51189
R560 VSS.n5 VSS.t15 6.73328
R561 VSS.t48 VSS.t35 1.13977
R562 VSS.t47 VSS.t38 1.13977
R563 VSS.n35 VSS.n12 1.10327
R564 VSS.n69 VSS.n68 0.890935
R565 VSS.n93 VSS.n92 0.824152
R566 VSS.n126 VSS.n13 0.551885
R567 VSS.t35 VSS.n6 4.98607
R568 VSS.n120 VSS.t34 0.402594
R569 VSS.t38 VSS.n54 0.402594
R570 VSS.n11 VSS.t37 3.76152
R571 VSS.n118 VSS 1.86023
R572 VSS.n2 VSS 1.14497
R573 VSS VSS.n0 1.09461
R574 x4.Y.n2 x4.Y.t15 1043.42
R575 x4.Y.n3 x4.Y.t16 1043.42
R576 x4.Y.n2 x4.Y.t13 1043.25
R577 x4.Y.n3 x4.Y.t18 1043.25
R578 x4.Y.n1 x4.Y.t12 1038.91
R579 x4.Y.n0 x4.Y.t19 1038.91
R580 x4.Y.n1 x4.Y.t14 1038.54
R581 x4.Y.n0 x4.Y.t17 1038.54
R582 x4.Y.n15 x4.Y.n10 312.226
R583 x4.Y.n14 x4.Y.n11 312.226
R584 x4.Y.n13 x4.Y.n12 311.849
R585 x4.Y.n5 x4.Y.t10 214.587
R586 x4.Y.n5 x4.Y.t11 214.587
R587 x4.Y.n17 x4.Y.n8 203.322
R588 x4.Y.n16 x4.Y.n9 202.97
R589 x4.Y.n16 x4.Y.n15 137.036
R590 x4.Y.n18 x4.Y.n17 51.9534
R591 x4.Y.n15 x4.Y.n14 45.5534
R592 x4.Y.n14 x4.Y.n13 45.177
R593 x4.Y.n17 x4.Y.n16 45.177
R594 x4.Y.n9 x4.Y.t0 40.0005
R595 x4.Y.n9 x4.Y.t1 40.0005
R596 x4.Y.n8 x4.Y.t2 40.0005
R597 x4.Y.n8 x4.Y.t3 40.0005
R598 x4.Y.n12 x4.Y.t8 27.5805
R599 x4.Y.n12 x4.Y.t9 27.5805
R600 x4.Y.n11 x4.Y.t6 27.5805
R601 x4.Y.n11 x4.Y.t7 27.5805
R602 x4.Y.n10 x4.Y.t4 27.5805
R603 x4.Y.n10 x4.Y.t5 27.5805
R604 x4.Y.n13 x4.Y 23.4672
R605 x4.Y.n7 x4.Y 21.2288
R606 x4.Y x4.Y.n18 12.5872
R607 x4.Y x4.Y.n7 10.8805
R608 x4.Y x4.Y.n6 8.97312
R609 x4.Y.n6 x4.Y.n5 8.22323
R610 x4.Y.n6 x4.Y.n4 7.91176
R611 x4.Y.n1 x4.Y.n2 5.898
R612 x4.Y.n0 x4.Y.n3 5.898
R613 x4.Y x4.Y.n7 3.62717
R614 x4.Y.n18 x4.Y 1.9205
R615 x4.Y.n4 x4.Y.n0 1.19112
R616 x4.Y.n4 x4.Y.n1 1.17863
R617 a_65_4595.n2 a_65_4595.t2 443.44
R618 a_65_4595.t1 a_65_4595.n5 390.067
R619 a_65_4595.n3 a_65_4595.t3 345.305
R620 a_65_4595.n3 a_65_4595.t6 296.969
R621 a_65_4595.n1 a_65_4595.t0 287.998
R622 a_65_4595.n0 a_65_4595.t7 263.173
R623 a_65_4595.n2 a_65_4595.t4 254.389
R624 a_65_4595.n0 a_65_4595.t5 227.826
R625 a_65_4595.n4 a_65_4595.n2 193.59
R626 a_65_4595.n1 a_65_4595.n0 152
R627 a_65_4595.n5 a_65_4595.n1 35.3396
R628 a_65_4595.n4 a_65_4595.n3 12.4401
R629 a_65_4595.n5 a_65_4595.n4 11.0742
C0 a_932_2929# a_881_2436# 0.3501f
C1 a_1561_2214# x3.D 0.21045f
C2 a_231_4595# a_929_4961# 0.19658f
C3 a_624_n1752# a_366_n1752# 1.15167f
C4 CLK x4.Y 0.77427f
C5 a_231_4595# a_419_4595# 0.10323f
C6 a_932_2929# a_1561_2214# 0.17077f
C7 x2.VLAT_PLUS x4.Y 2.16251f
C8 a_1097_4863# COMP_OUT 0.19207f
C9 a_366_n1752# x4.Y 0.73241f
C10 a_624_n1752# VINP 0.65494f
C11 a_1561_2214# x2.VLAT_MINUS 0.33021f
C12 a_504_4961# a_672_4707# 0.23924f
C13 a_231_4595# a_672_4707# 0.12805f
C14 x3.D x4.Y 1.39332f
C15 a_624_n1752# x2.VLAT_MINUS 0.13604f
C16 x2.VLAT_PLUS a_929_2214# 0.22271f
C17 a_419_4595# x3.D 0.1232f
C18 x2.VLAT_MINUS x4.Y 1.13659f
C19 a_624_n1752# x4.Y 0.74231f
C20 a_881_2436# a_929_2214# 0.34901f
C21 a_1570_n470# x2.VLAT_MINUS 0.85021f
C22 a_231_4595# x3.D 0.23046f
C23 CLK COMP_OUT 0.20424f
C24 a_1561_2214# a_929_2214# 0.17079f
C25 a_1570_n470# a_624_n1752# 1.07677f
C26 x2.VLAT_PLUS a_366_n1752# 0.53944f
C27 a_929_4961# a_1097_4863# 0.31046f
C28 a_1570_n470# x4.Y 0.60943f
C29 a_624_n1752# VINN 0.65468f
C30 a_881_2436# x2.VLAT_PLUS 0.31507f
C31 VINP a_366_n1752# 0.75123f
C32 x2.VLAT_MINUS x2.VLAT_PLUS 0.98953f
C33 a_1570_n470# VINN 0.7501f
C34 COMP_OUT VSS 0.71059f
C35 a_624_n1752# VSS 5.13676f
C36 a_1570_n470# VSS 3.25716f
C37 a_366_n1752# VSS 3.13019f
C38 a_929_2214# VSS 4.87383f
C39 a_881_2436# VSS 1.79574f
C40 x4.Y VSS 13.07054f
C41 a_1013_4961# VSS 0.20333f
C42 a_599_4961# VSS 0.17676f
C43 a_419_4595# VSS 2.09694f
C44 a_672_4707# VSS 0.27202f
C45 a_65_4595.t0 VSS 0.10006f
C46 a_65_4595.n0 VSS 0.15332f
C47 a_65_4595.n1 VSS 0.24581f
C48 a_65_4595.n2 VSS 0.19906f
C49 a_65_4595.n3 VSS 0.36141f
C50 a_65_4595.n4 VSS 0.58239f
C51 a_65_4595.n5 VSS 0.22944f
C52 a_65_4595.t1 VSS 0.12246f
C53 x4.Y.n0 VSS 0.42121f
C54 x4.Y.n1 VSS 0.41986f
C55 x4.Y.n2 VSS 0.81327f
C56 x4.Y.n3 VSS 0.81327f
C57 x4.Y.n4 VSS 0.21258f
C58 x4.Y.n5 VSS 0.57425f
C59 x4.Y.n6 VSS 1.28424f
C60 x4.Y.n7 VSS 2.49354f
C61 x4.Y.t4 VSS 0.99272f
C62 VSS.t11 VSS 0.77975f
C63 VSS.t27 VSS 1.06528f
C64 VSS.t1 VSS 1.22203f
C65 VSS.t19 VSS 0.26482f
C66 VSS.t7 VSS 0.27679f
C67 VDD.n0 VSS 1.96786f
C68 VDD.n3 VSS 6.73725f
C69 VDD.n4 VSS 0.24237f
C70 VDD.n6 VSS 0.49081f
C71 VDD.n7 VSS 0.10055f
C72 VDD.t19 VSS 0.19381f
C73 VDD.t6 VSS 0.12528f
C74 VDD.n16 VSS 0.10472f
C75 VDD.t23 VSS 0.15655f
C76 VDD.n17 VSS 0.11491f
C77 VDD.t47 VSS 1.0329f
C78 VDD.t21 VSS 0.11385f
C79 VDD.t17 VSS 0.2355f
C80 VDD.t29 VSS 0.19274f
C81 VDD.t1 VSS 0.56092f
C82 VDD.n24 VSS 0.13839f
C83 VDD.n25 VSS 0.1614f
C84 VDD.n31 VSS 0.1614f
C85 VDD.n39 VSS 0.1614f
C86 VDD.t34 VSS 0.34526f
C87 VDD.n44 VSS 0.13839f
C88 VDD.t33 VSS 0.18148f
C89 VDD.t35 VSS 0.1614f
C90 VDD.t31 VSS 0.1614f
C91 VDD.t9 VSS 0.18148f
C92 VDD.n70 VSS 0.10418f
C93 VDD.t14 VSS 0.6974f
C94 VDD.t13 VSS 0.27155f
C95 VDD.t44 VSS 0.27155f
C96 VDD.n80 VSS 0.17561f
C97 VDD.t5 VSS 0.69976f
C98 VDD.n81 VSS 0.27343f
C99 VDD.t27 VSS 0.60092f
C100 VDD.n87 VSS 0.27802f
C101 VDD.t4 VSS 0.27155f
C102 VDD.t26 VSS 0.27155f
C103 VDD.t43 VSS 0.3952f
C104 VDD.n97 VSS 0.36783f
C105 VDD.t42 VSS 0.30353f
C106 VDD.n103 VSS 0.41896f
C107 VDD.t22 VSS 0.27155f
C108 VDD.n104 VSS 0.12414f
C109 VDD.n111 VSS 0.12414f
C110 VDD.n120 VSS 0.14237f
C111 VDD.t32 VSS 0.10926f
C112 VDD.n121 VSS 0.27802f
C113 VDD.n122 VSS 0.17112f
C114 VDD.t36 VSS 0.10926f
C115 VDD.n123 VSS 0.14237f
C116 VDD.n125 VSS 0.44571f
C117 VDD.t37 VSS 0.59599f
C118 VDD.n129 VSS 0.12414f
C119 VDD.n135 VSS 0.41896f
C120 VDD.t15 VSS 0.27155f
C121 VDD.n136 VSS 0.12414f
C122 VDD.t11 VSS 0.30353f
C123 VDD.n137 VSS 0.3676f
C124 VDD.t12 VSS 1.15455f
.ends
