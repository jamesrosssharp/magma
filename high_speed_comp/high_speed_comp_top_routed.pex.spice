* NGSPICE file created from high_speed_comp_top_routed.ext - technology: sky130A

.subckt high_speed_comp_top_routed VINP VINN VDD VSS CLK COMP_OUT
X0 a_504_4961# a_231_4595# a_419_4595# VDD.t2 sky130_fd_pr__pfet_01v8_hvt ad=0.06825 pd=0.745 as=0.05775 ps=0.695 w=0.42 l=0.15
X1 VDD.t26 a_672_4707# a_599_4961# VDD.t25 sky130_fd_pr__pfet_01v8_hvt ad=0.17887 pd=1.26 as=0.07665 ps=0.785 w=0.42 l=0.15
X2 a_929_2214# a_881_2436# VSS.t7 VSS.t6 sky130_fd_pr__nfet_01v8 ad=0.29 pd=2.58 as=0.29 ps=2.58 w=1 l=0.15
X3 a_929_4961# a_65_4595.t4 a_672_4707# VDD.t27 sky130_fd_pr__pfet_01v8_hvt ad=0.0567 pd=0.69 as=0.1095 ps=1.075 w=0.42 l=0.15
X4 VDD.t14 a_1097_4863# a_1013_4961# VDD.t13 sky130_fd_pr__pfet_01v8_hvt ad=0.1113 pd=1.37 as=0.0882 ps=0.84 w=0.42 l=0.15
X5 a_929_4961# a_231_4595# a_672_4707# VSS.t3 sky130_fd_pr__special_nfet_01v8 ad=0.0684 pd=0.74 as=0.0989 ps=0.995 w=0.36 l=0.15
X6 x3.D a_1561_2214# VDD.t31 VDD.t30 sky130_fd_pr__pfet_01v8 ad=0.29 pd=2.58 as=0.29 ps=2.58 w=1 l=0.15
X7 x2.VLAT_PLUS x4.Y.t17 VDD.t11 VDD.t10 sky130_fd_pr__pfet_01v8 ad=0.825 pd=5.33 as=1.55 ps=10.62 w=5 l=0.15
X8 a_231_4595# a_65_4595.t5 VSS.t21 VSS.t20 sky130_fd_pr__nfet_01v8 ad=0.1092 pd=1.36 as=0.0567 ps=0.69 w=0.42 l=0.15
X9 a_1561_2214# x2.VLAT_MINUS a_929_2214# VSS.t28 sky130_fd_pr__nfet_01v8 ad=0.29 pd=2.58 as=0.29 ps=2.58 w=1 l=0.15
X10 COMP_OUT a_1097_4863# VDD.t16 VDD.t15 sky130_fd_pr__pfet_01v8_hvt ad=0.135 pd=1.27 as=0.135 ps=1.27 w=1 l=0.15
X11 x4.Y.t4 CLK VDD.t47 VDD.t46 sky130_fd_pr__pfet_01v8_hvt ad=0.14 pd=1.28 as=0.305 ps=2.61 w=1 l=0.15
X12 VDD.t50 CLK x4.Y.t7 VDD.t49 sky130_fd_pr__pfet_01v8_hvt ad=0.14 pd=1.28 as=0.14 ps=1.28 w=1 l=0.15
X13 COMP_OUT a_1097_4863# VSS.t15 VSS.t14 sky130_fd_pr__nfet_01v8 ad=0.08775 pd=0.92 as=0.08775 ps=0.92 w=0.65 l=0.15
X14 VDD.t38 CLK a_65_4595.t1 VDD.t48 sky130_fd_pr__pfet_01v8_hvt ad=0.0864 pd=0.91 as=0.1664 ps=1.8 w=0.64 l=0.15
X15 x4.Y.t8 CLK VDD.t50 VDD.t54 sky130_fd_pr__pfet_01v8_hvt ad=0.14 pd=1.28 as=0.14 ps=1.28 w=1 l=0.15
X16 VSS.t35 VDD.t58 VSS.t34 VSS.t33 sky130_fd_pr__nfet_01v8 ad=0.143 pd=1.62 as=0 ps=0 w=0.55 l=0.59
X17 x2.VLAT_MINUS x4.Y.t15 VDD.t24 VDD.t23 sky130_fd_pr__pfet_01v8 ad=0.825 pd=5.33 as=1.55 ps=10.62 w=5 l=0.15
X18 VDD.t5 x4.Y.t14 x2.VLAT_MINUS VDD.t4 sky130_fd_pr__pfet_01v8 ad=1.55 pd=10.62 as=0.825 ps=5.33 w=5 l=0.15
X19 VDD.t52 CLK x4.Y.t5 VDD.t51 sky130_fd_pr__pfet_01v8_hvt ad=0.14 pd=1.28 as=0.14 ps=1.28 w=1 l=0.15
X20 a_932_2929# a_881_2436# VDD.t7 VDD.t6 sky130_fd_pr__pfet_01v8 ad=0.29 pd=2.58 as=0.29 ps=2.58 w=1 l=0.15
X21 a_1570_n470# x4.Y.t13 VDD.t5 VDD.t19 sky130_fd_pr__pfet_01v8 ad=0.825 pd=5.33 as=1.55 ps=10.62 w=5 l=0.15
X22 VDD.t16 a_929_4961# a_1097_4863# VDD.t36 sky130_fd_pr__pfet_01v8_hvt ad=0.135 pd=1.27 as=0.27 ps=2.54 w=1 l=0.15
X23 VDD.t40 x4.Y.t12 a_1570_n470# VDD.t39 sky130_fd_pr__pfet_01v8 ad=1.55 pd=10.62 as=0.825 ps=5.33 w=5 l=0.15
X24 VDD.t56 CLK x4.Y.t9 VDD.t55 sky130_fd_pr__pfet_01v8_hvt ad=0.345 pd=2.69 as=0.14 ps=1.28 w=1 l=0.15
X25 VSS.t15 a_929_4961# a_1097_4863# VSS.t31 sky130_fd_pr__nfet_01v8 ad=0.08775 pd=0.92 as=0.169 ps=1.82 w=0.65 l=0.15
X26 VSS.t38 VDD.t57 VSS.t37 VSS.t36 sky130_fd_pr__nfet_01v8 ad=0.143 pd=1.62 as=0 ps=0 w=0.55 l=0.59
X27 a_504_4961# a_65_4595.t3 a_419_4595# VSS.t4 sky130_fd_pr__special_nfet_01v8 ad=0.0621 pd=0.705 as=0.0813 ps=0.83 w=0.36 l=0.15
X28 VSS.t19 a_672_4707# a_630_4595# VSS.t18 sky130_fd_pr__nfet_01v8 ad=0.12095 pd=1.085 as=0.0696 ps=0.765 w=0.42 l=0.15
X29 x4.Y.t6 CLK VDD.t52 VDD.t53 sky130_fd_pr__pfet_01v8_hvt ad=0.14 pd=1.28 as=0.14 ps=1.28 w=1 l=0.15
X30 a_1561_2214# x2.VLAT_MINUS a_932_2929# VDD.t32 sky130_fd_pr__pfet_01v8 ad=0.29 pd=2.58 as=0.29 ps=2.58 w=1 l=0.15
X31 VSS.t11 x4.Y.t11 a_624_n1752# VSS.t30 sky130_fd_pr__nfet_01v8_lvt ad=0.725 pd=5.29 as=1.45 ps=10.58 w=5 l=1
X32 a_419_4595# x3.D VSS.t1 VSS.t0 sky130_fd_pr__nfet_01v8 ad=0.0813 pd=0.83 as=0.1092 ps=1.36 w=0.42 l=0.15
X33 a_630_4595# a_231_4595# a_504_4961# VSS.t2 sky130_fd_pr__special_nfet_01v8 ad=0.0696 pd=0.765 as=0.0621 ps=0.705 w=0.36 l=0.15
X34 a_929_2214# x2.VLAT_PLUS a_881_2436# VSS.t22 sky130_fd_pr__nfet_01v8 ad=0.29 pd=2.58 as=0.29 ps=2.58 w=1 l=0.15
X35 x2.VLAT_PLUS x2.VLAT_MINUS VDD.t34 VDD.t33 sky130_fd_pr__pfet_01v8 ad=0.29 pd=2.58 as=0.29 ps=2.58 w=1 l=0.15
X36 VDD.t22 VSS.t48 VDD.t21 VDD.t20 sky130_fd_pr__pfet_01v8_hvt ad=0.2262 pd=2.26 as=0 ps=0 w=0.87 l=0.59
X37 a_624_n1752# VINN a_1570_n470# VSS.t24 sky130_fd_pr__nfet_01v8_lvt ad=0.725 pd=5.29 as=1.45 ps=10.58 w=5 l=1
X38 VSS.t21 CLK a_65_4595.t0 VSS.t41 sky130_fd_pr__nfet_01v8 ad=0.0567 pd=0.69 as=0.1092 ps=1.36 w=0.42 l=0.15
X39 VDD.t18 a_1097_4863# COMP_OUT VDD.t17 sky130_fd_pr__pfet_01v8_hvt ad=0.26 pd=2.52 as=0.135 ps=1.27 w=1 l=0.15
X40 VSS.t17 a_1097_4863# COMP_OUT VSS.t16 sky130_fd_pr__nfet_01v8 ad=0.169 pd=1.82 as=0.08775 ps=0.92 w=0.65 l=0.15
X41 a_366_n1752# x4.Y.t19 VDD.t9 VDD.t8 sky130_fd_pr__pfet_01v8 ad=0.825 pd=5.33 as=1.55 ps=10.62 w=5 l=0.15
X42 x2.VLAT_PLUS x2.VLAT_MINUS a_366_n1752# VSS.t29 sky130_fd_pr__nfet_01v8 ad=0.29 pd=2.58 as=0.29 ps=2.58 w=1 l=0.15
X43 a_672_4707# a_504_4961# VSS.t19 VSS.t32 sky130_fd_pr__nfet_01v8 ad=0.0989 pd=0.995 as=0.12095 ps=1.085 w=0.64 l=0.15
X44 a_1055_4595# a_65_4595.t2 a_929_4961# VSS.t5 sky130_fd_pr__special_nfet_01v8 ad=0.066 pd=0.745 as=0.0684 ps=0.74 w=0.36 l=0.15
X45 VSS.t13 a_1097_4863# a_1055_4595# VSS.t12 sky130_fd_pr__nfet_01v8 ad=0.1092 pd=1.36 as=0.066 ps=0.745 w=0.42 l=0.15
X46 x3.D a_1561_2214# VSS.t27 VSS.t26 sky130_fd_pr__nfet_01v8 ad=0.29 pd=2.58 as=0.29 ps=2.58 w=1 l=0.15
X47 VDD.t11 x4.Y.t18 a_366_n1752# VDD.t12 sky130_fd_pr__pfet_01v8 ad=1.55 pd=10.62 as=0.825 ps=5.33 w=5 l=0.15
X48 VDD.t44 VSS.t47 VDD.t43 VDD.t42 sky130_fd_pr__pfet_01v8_hvt ad=0.2262 pd=2.26 as=0 ps=0 w=0.87 l=0.59
X49 a_1570_n470# VINN a_624_n1752# VSS.t25 sky130_fd_pr__nfet_01v8_lvt ad=1.45 pd=10.58 as=0.725 ps=5.29 w=5 l=1
X50 a_419_4595# x3.D VDD.t1 VDD.t0 sky130_fd_pr__pfet_01v8_hvt ad=0.05775 pd=0.695 as=0.1092 ps=1.36 w=0.42 l=0.15
X51 a_1013_4961# a_231_4595# a_929_4961# VDD.t3 sky130_fd_pr__pfet_01v8_hvt ad=0.0882 pd=0.84 as=0.0567 ps=0.69 w=0.42 l=0.15
X52 a_599_4961# a_65_4595.t6 a_504_4961# VDD.t35 sky130_fd_pr__pfet_01v8_hvt ad=0.07665 pd=0.785 as=0.06825 ps=0.745 w=0.42 l=0.15
X53 a_932_2929# x2.VLAT_PLUS a_881_2436# VDD.t28 sky130_fd_pr__pfet_01v8 ad=0.29 pd=2.58 as=0.29 ps=2.58 w=1 l=0.15
X54 a_624_n1752# x4.Y.t10 VSS.t11 VSS.t10 sky130_fd_pr__nfet_01v8_lvt ad=1.45 pd=10.58 as=0.725 ps=5.29 w=5 l=1
X55 x4.Y.t2 CLK VSS.t43 VSS.t44 sky130_fd_pr__nfet_01v8 ad=0.0588 pd=0.7 as=0.0588 ps=0.7 w=0.42 l=0.15
X56 VDD.t24 x2.VLAT_PLUS x2.VLAT_MINUS VDD.t29 sky130_fd_pr__pfet_01v8 ad=0.29 pd=2.58 as=0.29 ps=2.58 w=1 l=0.15
X57 a_672_4707# a_504_4961# VDD.t26 VDD.t45 sky130_fd_pr__pfet_01v8_hvt ad=0.1095 pd=1.075 as=0.17887 ps=1.26 w=0.75 l=0.15
X58 VSS.t46 CLK x4.Y.t3 VSS.t45 sky130_fd_pr__nfet_01v8 ad=0.1659 pd=1.63 as=0.0588 ps=0.7 w=0.42 l=0.15
X59 a_1570_n470# x2.VLAT_PLUS x2.VLAT_MINUS VSS.t23 sky130_fd_pr__nfet_01v8 ad=0.29 pd=2.58 as=0.29 ps=2.58 w=1 l=0.15
X60 a_231_4595# a_65_4595.t7 VDD.t38 VDD.t37 sky130_fd_pr__pfet_01v8_hvt ad=0.1664 pd=1.8 as=0.0864 ps=0.91 w=0.64 l=0.15
X61 x4.Y.t0 CLK VSS.t40 VSS.t39 sky130_fd_pr__nfet_01v8 ad=0.0588 pd=0.7 as=0.1386 ps=1.5 w=0.42 l=0.15
X62 VDD.t34 x4.Y.t16 x2.VLAT_PLUS VDD.t41 sky130_fd_pr__pfet_01v8 ad=1.55 pd=10.62 as=0.825 ps=5.33 w=5 l=0.15
X63 a_366_n1752# VINP a_624_n1752# VSS.t9 sky130_fd_pr__nfet_01v8_lvt ad=1.45 pd=10.58 as=0.725 ps=5.29 w=5 l=1
X64 a_624_n1752# VINP a_366_n1752# VSS.t8 sky130_fd_pr__nfet_01v8_lvt ad=0.725 pd=5.29 as=1.45 ps=10.58 w=5 l=1
X65 VSS.t43 CLK x4.Y.t1 VSS.t42 sky130_fd_pr__nfet_01v8 ad=0.0588 pd=0.7 as=0.0588 ps=0.7 w=0.42 l=0.15
R0 VDD.n138 VDD.n75 3031.76
R1 VDD.n138 VDD.n74 3031.76
R2 VDD.n129 VDD.n4 3031.76
R3 VDD.n101 VDD.n98 3031.76
R4 VDD.n106 VDD.n98 3031.76
R5 VDD.n111 VDD.n83 3031.76
R6 VDD.n135 VDD.n77 2290.59
R7 VDD.n135 VDD.n76 2290.59
R8 VDD.n103 VDD.n94 2290.59
R9 VDD.n103 VDD.n95 2290.59
R10 VDD.n84 VDD.n80 1510.59
R11 VDD.n91 VDD.n86 1510.59
R12 VDD.n69 VDD.n25 1312.94
R13 VDD.n51 VDD.n45 1312.94
R14 VDD.n131 VDD.n80 1238.82
R15 VDD.n113 VDD.n91 1238.82
R16 VDD.n17 VDD.t42 761.74
R17 VDD.n92 VDD.n89 755.294
R18 VDD.n89 VDD.n87 755.294
R19 VDD.n28 VDD.n27 755.294
R20 VDD.n28 VDD.n24 755.294
R21 VDD.n42 VDD.n41 755.294
R22 VDD.n42 VDD.n39 755.294
R23 VDD.n36 VDD.n31 755.294
R24 VDD.n36 VDD.n33 755.294
R25 VDD.n77 VDD.n75 741.178
R26 VDD.n131 VDD.n77 741.178
R27 VDD.n76 VDD.n74 741.178
R28 VDD.n129 VDD.n76 741.178
R29 VDD.n113 VDD.n94 741.178
R30 VDD.n101 VDD.n94 741.178
R31 VDD.n111 VDD.n95 741.178
R32 VDD.n106 VDD.n95 741.178
R33 VDD.t17 VDD.t20 739.875
R34 VDD.t42 VDD.t55 736.917
R35 VDD.t13 VDD.t36 621.495
R36 VDD.n85 VDD.n84 557.648
R37 VDD.n87 VDD.n85 557.648
R38 VDD.n125 VDD.n87 557.648
R39 VDD.n125 VDD.n86 557.648
R40 VDD.n90 VDD.n80 557.648
R41 VDD.n92 VDD.n90 557.648
R42 VDD.n120 VDD.n92 557.648
R43 VDD.n120 VDD.n91 557.648
R44 VDD.n67 VDD.n27 557.648
R45 VDD.n62 VDD.n27 557.648
R46 VDD.n62 VDD.n31 557.648
R47 VDD.n55 VDD.n31 557.648
R48 VDD.n55 VDD.n41 557.648
R49 VDD.n51 VDD.n41 557.648
R50 VDD.n69 VDD.n24 557.648
R51 VDD.n61 VDD.n24 557.648
R52 VDD.n61 VDD.n33 557.648
R53 VDD.n56 VDD.n33 557.648
R54 VDD.n56 VDD.n39 557.648
R55 VDD.n49 VDD.n39 557.648
R56 VDD.t37 VDD.t0 556.386
R57 VDD.t20 VDD.n22 544.548
R58 VDD.n5 VDD.n7 528.84
R59 VDD.n115 VDD.n5 528.84
R60 VDD.n22 VDD.t46 440.966
R61 VDD.t25 VDD.t45 390.654
R62 VDD.t29 VDD.n121 352.187
R63 VDD.n124 VDD.t33 352.187
R64 VDD.t3 VDD.t13 337.384
R65 VDD.n100 VDD.n99 323.526
R66 VDD.n139 VDD.n73 323.389
R67 VDD.t35 VDD.t25 304.829
R68 VDD.t2 VDD.t35 281.154
R69 VDD.t45 VDD.t27 281.154
R70 VDD.t6 VDD.n26 264.262
R71 VDD.t28 VDD.n26 264.262
R72 VDD.t28 VDD.n32 264.262
R73 VDD.t32 VDD.n32 264.262
R74 VDD.t32 VDD.n40 264.262
R75 VDD.t30 VDD.n40 264.262
R76 VDD.t51 VDD.t46 254.518
R77 VDD.t53 VDD.t51 254.518
R78 VDD.t49 VDD.t53 254.518
R79 VDD.t54 VDD.t49 254.518
R80 VDD.t55 VDD.t54 254.518
R81 VDD.t0 VDD.t2 251.559
R82 VDD.n99 VDD.n97 251.405
R83 VDD.n140 VDD.n139 250.345
R84 VDD.t48 VDD.t37 248.599
R85 VDD.t27 VDD.t3 248.599
R86 VDD.t36 VDD.t15 248.599
R87 VDD.t15 VDD.t17 248.599
R88 VDD.n134 VDD.n133 244.329
R89 VDD.n102 VDD.n93 244.329
R90 VDD.n134 VDD.n79 242.825
R91 VDD.n102 VDD.n96 242.825
R92 VDD.n68 VDD.n25 237.584
R93 VDD.n50 VDD.n45 237.584
R94 VDD.n22 VDD.n21 213.119
R95 VDD.n52 VDD.n44 139.976
R96 VDD.n115 VDD.n114 132.142
R97 VDD.n132 VDD.n7 132.142
R98 VDD.n66 VDD.n65 121.138
R99 VDD.n138 VDD.t8 117.906
R100 VDD.t39 VDD.n98 117.906
R101 VDD.t12 VDD.n136 107.025
R102 VDD.n136 VDD.t10 107.025
R103 VDD.n122 VDD.t41 107.025
R104 VDD.t23 VDD.n88 107.025
R105 VDD.n104 VDD.t4 107.025
R106 VDD.t19 VDD.n104 107.025
R107 VDD.n121 VDD.n90 92.5005
R108 VDD.n117 VDD.n90 92.5005
R109 VDD.n121 VDD.n120 92.5005
R110 VDD.n120 VDD.n119 92.5005
R111 VDD.n125 VDD.n124 92.5005
R112 VDD.n5 VDD.n125 92.5005
R113 VDD.n124 VDD.n85 92.5005
R114 VDD.n5 VDD.n85 92.5005
R115 VDD.n69 VDD.t6 92.5005
R116 VDD.n70 VDD.n69 92.5005
R117 VDD.t28 VDD.n61 92.5005
R118 VDD.n61 VDD.n60 92.5005
R119 VDD.n56 VDD.t32 92.5005
R120 VDD.n57 VDD.n56 92.5005
R121 VDD.n49 VDD.n48 92.5005
R122 VDD.n51 VDD.t30 92.5005
R123 VDD.n52 VDD.n51 92.5005
R124 VDD.t32 VDD.n55 92.5005
R125 VDD.n55 VDD.n54 92.5005
R126 VDD.n62 VDD.t28 92.5005
R127 VDD.n63 VDD.n62 92.5005
R128 VDD.n67 VDD.n66 92.5005
R129 VDD.n46 VDD.n44 83.2475
R130 VDD.n118 VDD.n116 80.5652
R131 VDD.n116 VDD.n5 80.5652
R132 VDD.n37 VDD.n30 80.5652
R133 VDD.n38 VDD.n37 80.5652
R134 VDD.n64 VDD.n29 80.5652
R135 VDD.n34 VDD.n29 80.5652
R136 VDD.n114 VDD.n93 79.0593
R137 VDD.n100 VDD.n93 79.0593
R138 VDD.n133 VDD.n73 79.0593
R139 VDD.n133 VDD.n132 79.0593
R140 VDD.n68 VDD.n67 70.7763
R141 VDD.n50 VDD.n49 70.7763
R142 VDD.n123 VDD.t29 65.0195
R143 VDD.t33 VDD.n123 65.0195
R144 VDD.n53 VDD.n43 61.6559
R145 VDD.n117 VDD.n7 59.4829
R146 VDD.n118 VDD.n117 59.4829
R147 VDD.n119 VDD.n118 59.4829
R148 VDD.n119 VDD.n115 59.4829
R149 VDD.n66 VDD.n64 59.4829
R150 VDD.n64 VDD.n63 59.4829
R151 VDD.n63 VDD.n30 59.4829
R152 VDD.n54 VDD.n30 59.4829
R153 VDD.n54 VDD.n53 59.4829
R154 VDD.n53 VDD.n52 59.4829
R155 VDD.n106 VDD.n105 46.2505
R156 VDD.n107 VDD.n106 46.2505
R157 VDD.n112 VDD.n111 46.2505
R158 VDD.n111 VDD.n110 46.2505
R159 VDD.n113 VDD.n112 46.2505
R160 VDD.n114 VDD.n113 46.2505
R161 VDD.n105 VDD.n101 46.2505
R162 VDD.n101 VDD.n100 46.2505
R163 VDD.n123 VDD.n89 46.2505
R164 VDD.n116 VDD.n89 46.2505
R165 VDD.n131 VDD.n130 46.2505
R166 VDD.n132 VDD.n131 46.2505
R167 VDD.n137 VDD.n75 46.2505
R168 VDD.n75 VDD.n73 46.2505
R169 VDD.n137 VDD.n74 46.2505
R170 VDD.n74 VDD.n72 46.2505
R171 VDD.n130 VDD.n129 46.2505
R172 VDD.n129 VDD.n128 46.2505
R173 VDD.n45 VDD.n44 46.2505
R174 VDD.n65 VDD.n25 46.2505
R175 VDD.n28 VDD.n26 46.2505
R176 VDD.n29 VDD.n28 46.2505
R177 VDD.n42 VDD.n40 46.2505
R178 VDD.n43 VDD.n42 46.2505
R179 VDD.n36 VDD.n32 46.2505
R180 VDD.n37 VDD.n36 46.2505
R181 VDD.n84 VDD.n4 42.3534
R182 VDD.n86 VDD.n83 42.3534
R183 VDD.n123 VDD.n122 35.0144
R184 VDD.n123 VDD.n88 35.0144
R185 VDD.n8 VDD.n3 47.4632
R186 VDD.t8 VDD.n137 31.7112
R187 VDD.n137 VDD.t12 31.7112
R188 VDD.n130 VDD.t10 31.7112
R189 VDD.n130 VDD.t41 31.7112
R190 VDD.n112 VDD.t23 31.7112
R191 VDD.n112 VDD.t4 31.7112
R192 VDD.n105 VDD.t19 31.7112
R193 VDD.n105 VDD.t39 31.7112
R194 VDD.t16 VDD.n9 37.4011
R195 VDD.n15 VDD.t50 32.9936
R196 VDD.n13 VDD.t52 5.38743
R197 VDD.n10 VDD.t18 31.6517
R198 VDD.t52 VDD.n14 29.036
R199 VDD.t48 VDD.n0 631.112
R200 VDD.n1 VDD.t38 5.04016
R201 VDD.t1 VDD.n1 5.54548
R202 VDD.n14 VDD.t50 4.94188
R203 VDD.n13 VDD.t47 24.9639
R204 VDD.t30 VDD.n50 16.7394
R205 VDD.t6 VDD.n68 16.7394
R206 VDD.n15 VDD.t56 4.38186
R207 VDD.t26 VDD.n3 11.6008
R208 VDD.n8 VDD.t14 21.1105
R209 VDD.n71 VDD.t7 14.4208
R210 VDD.t31 VDD.n35 14.4208
R211 VDD.t56 VDD.n19 14.2735
R212 VDD.n21 VDD.t21 14.2735
R213 VDD.n110 VDD.n96 13.8562
R214 VDD.n128 VDD.n79 13.8562
R215 VDD.n126 VDD.n5 13.5861
R216 VDD.n108 VDD.n107 13.3283
R217 VDD.n78 VDD.n72 13.2624
R218 VDD.n12 VDD.t47 3.79208
R219 VDD.n99 VDD.n98 11.0403
R220 VDD.n122 VDD.n4 10.8829
R221 VDD.n5 VDD.n4 10.8829
R222 VDD.n88 VDD.n83 10.8829
R223 VDD.n139 VDD.n138 10.8829
R224 VDD.n136 VDD.n135 10.8829
R225 VDD.n135 VDD.n134 10.8829
R226 VDD.n104 VDD.n103 10.8829
R227 VDD.n103 VDD.n102 10.8829
R228 VDD.n0 VDD.n71 10.5356
R229 VDD.n46 VDD.n0 9.5505
R230 VDD.n127 VDD.t34 9.3005
R231 VDD.n78 VDD.t11 9.3005
R232 VDD.t9 VDD.n140 9.3005
R233 VDD.n97 VDD.t40 9.3005
R234 VDD.t5 VDD.n108 9.3005
R235 VDD.n109 VDD.t24 9.3005
R236 VDD.n23 VDD.n0 9.3005
R237 VDD.n59 VDD.n0 9.3005
R238 VDD.n0 VDD.n16 9.3005
R239 VDD.n0 VDD.n58 9.3005
R240 VDD.n47 VDD.n0 9.3005
R241 VDD.n2 VDD.n8 1.62567
R242 VDD.n9 VDD.t14 5.77756
R243 VDD.n9 VDD.n2 1.76272
R244 VDD.n2 VDD.n10 1.62567
R245 VDD.n11 VDD.n2 1.97608
R246 VDD.n6 VDD.n20 9.3005
R247 VDD.n6 VDD.t21 9.3005
R248 VDD.n21 VDD.n12 3.79208
R249 VDD.n6 VDD.n12 2.75546
R250 VDD.n13 VDD.n6 1.95779
R251 VDD.n6 VDD.n14 2.18056
R252 VDD.n15 VDD.n6 2.46057
R253 VDD.n19 VDD.n6 9.3005
R254 VDD.n6 VDD.n18 9.3005
R255 VDD.n11 VDD.t18 14.3861
R256 VDD.n5 VDD.n83 11.5535
R257 VDD.n109 VDD.n81 7.45617
R258 VDD.n127 VDD.n81 7.39019
R259 VDD.n58 VDD.n35 6.77477
R260 VDD.n107 VDD.n97 6.33452
R261 VDD.n140 VDD.n72 6.33452
R262 VDD.n57 VDD.n38 5.91395
R263 VDD.n60 VDD.n16 5.53968
R264 VDD.n110 VDD.n109 5.27885
R265 VDD.n128 VDD.n127 5.21287
R266 VDD.n82 VDD.n126 4.53781
R267 VDD.n18 VDD.t44 4.36875
R268 VDD.n20 VDD.t22 4.36875
R269 VDD.n48 VDD.n46 4.34202
R270 VDD.t43 VDD.n17 4.33016
R271 VDD.n59 VDD.n34 3.96775
R272 VDD.n71 VDD.n70 3.85547
R273 VDD.n34 VDD.n23 3.51863
R274 VDD.n18 VDD.t57 3.50526
R275 VDD.n20 VDD.t58 3.50526
R276 VDD.n48 VDD.n47 3.14436
R277 VDD.n10 VDD.t16 9.06342
R278 VDD.n65 VDD.t7 2.91696
R279 VDD.n43 VDD.t31 2.91696
R280 VDD.n6 VDD.n17 2.76497
R281 VDD.n70 VDD.n23 2.39582
R282 VDD.n60 VDD.n59 1.9467
R283 VDD.n0 VDD.t9 1.29581
R284 VDD.n58 VDD.n57 1.19816
R285 VDD.t58 VDD.t21 1.16875
R286 VDD.t57 VDD.t43 0.863992
R287 VDD.n47 VDD.n35 0.711611
R288 VDD.n126 VDD.n81 0.632835
R289 VDD.n79 VDD.n78 0.594314
R290 VDD.t34 VDD.n82 0.555508
R291 VDD.t24 VDD.n82 0.555508
R292 VDD.n108 VDD.n96 0.528335
R293 VDD.t5 VDD.t40 0.466125
R294 VDD.t34 VDD.t11 0.466125
R295 VDD.t24 VDD.t5 0.466125
R296 VDD.t9 VDD.t11 0.464563
R297 VDD.n38 VDD.n16 0.374769
R298 VDD.n19 VDD.t44 0.305262
R299 VDD.t22 VDD.n11 5.6556
R300 VDD.n0 VDD.n3 1.79632
R301 VDD.n0 VDD.n2 1.68644
R302 VDD.n6 VDD.n2 1.54858
R303 VDD.n1 VDD.n0 1.31015
R304 VSS.n112 VSS.n17 24836
R305 VSS.n80 VSS.n17 6156.29
R306 VSS.n112 VSS.n111 6073.79
R307 VSS.n84 VSS.n79 5684.03
R308 VSS.n82 VSS.n79 5684.03
R309 VSS.n110 VSS.n54 5684.03
R310 VSS.n110 VSS.n55 5684.03
R311 VSS.n105 VSS.n60 3425.61
R312 VSS.n105 VSS.n59 3425.61
R313 VSS.n88 VSS.n73 3333.03
R314 VSS.n88 VSS.n69 3333.03
R315 VSS.n124 VSS.n16 2126.44
R316 VSS.n124 VSS.n15 2126.44
R317 VSS.n52 VSS.n19 2126.44
R318 VSS.n52 VSS.n18 2126.44
R319 VSS.n91 VSS.n72 2126.44
R320 VSS.n92 VSS.n72 2126.44
R321 VSS.n102 VSS.n62 2126.44
R322 VSS.n102 VSS.n63 2126.44
R323 VSS.n59 VSS.n54 2056.91
R324 VSS.n94 VSS.n59 2056.91
R325 VSS.n68 VSS.n60 2056.91
R326 VSS.n60 VSS.n55 2056.91
R327 VSS.n94 VSS.n69 2039.53
R328 VSS.n73 VSS.n68 2039.53
R329 VSS.n84 VSS.n73 2039.53
R330 VSS.n82 VSS.n69 2039.53
R331 VSS.n97 VSS.n67 1272.06
R332 VSS.n97 VSS.n66 1272.06
R333 VSS.n28 VSS.n27 1210.97
R334 VSS.n27 VSS.n23 1210.97
R335 VSS.n31 VSS.n29 1210.97
R336 VSS.n31 VSS.n24 1210.97
R337 VSS.n37 VSS.n33 1210.97
R338 VSS.n37 VSS.n35 1210.97
R339 VSS.n122 VSS.n121 1205.01
R340 VSS.n118 VSS.n117 1198.25
R341 VSS.n33 VSS.n16 915.471
R342 VSS.n42 VSS.n33 915.471
R343 VSS.n42 VSS.n29 915.471
R344 VSS.n46 VSS.n29 915.471
R345 VSS.n46 VSS.n28 915.471
R346 VSS.n28 VSS.n19 915.471
R347 VSS.n35 VSS.n15 915.471
R348 VSS.n41 VSS.n35 915.471
R349 VSS.n41 VSS.n24 915.471
R350 VSS.n47 VSS.n24 915.471
R351 VSS.n47 VSS.n23 915.471
R352 VSS.n23 VSS.n18 915.471
R353 VSS.n66 VSS.n62 816.971
R354 VSS.n91 VSS.n66 816.971
R355 VSS.n92 VSS.n67 816.971
R356 VSS.n67 VSS.n63 816.971
R357 VSS.t33 VSS.t16 712.273
R358 VSS.n122 VSS.n17 587.619
R359 VSS.t31 VSS.t12 542.821
R360 VSS.n123 VSS.t6 538.082
R361 VSS.n34 VSS.t6 538.082
R362 VSS.t22 VSS.n34 538.082
R363 VSS.t22 VSS.n26 538.082
R364 VSS.t28 VSS.n26 538.082
R365 VSS.t28 VSS.n25 538.082
R366 VSS.n25 VSS.t26 538.082
R367 VSS.n53 VSS.t26 538.082
R368 VSS.n117 VSS.t33 528.46
R369 VSS.n117 VSS.n116 436.555
R370 VSS.t45 VSS.t36 434.553
R371 VSS.n115 VSS.n112 406.014
R372 VSS.t8 VSS.n80 399.104
R373 VSS.n89 VSS.t9 399.104
R374 VSS.n104 VSS.t24 399.104
R375 VSS.n111 VSS.t25 399.104
R376 VSS.t18 VSS.t32 364.752
R377 VSS.t5 VSS.t3 304.44
R378 VSS.t29 VSS.n91 292.5
R379 VSS.n91 VSS.n64 292.5
R380 VSS.n62 VSS.t23 292.5
R381 VSS.n100 VSS.n62 292.5
R382 VSS.n63 VSS.t23 292.5
R383 VSS.n65 VSS.n63 292.5
R384 VSS.n92 VSS.t29 292.5
R385 VSS.n93 VSS.n92 292.5
R386 VSS.t6 VSS.n15 292.5
R387 VSS.n15 VSS.n14 292.5
R388 VSS.t22 VSS.n41 292.5
R389 VSS.n41 VSS.n40 292.5
R390 VSS.n47 VSS.t28 292.5
R391 VSS.n48 VSS.n47 292.5
R392 VSS.n18 VSS.t26 292.5
R393 VSS.n50 VSS.n18 292.5
R394 VSS.n19 VSS.t26 292.5
R395 VSS.n20 VSS.n19 292.5
R396 VSS.t28 VSS.n46 292.5
R397 VSS.n46 VSS.n45 292.5
R398 VSS.n42 VSS.t22 292.5
R399 VSS.n43 VSS.n42 292.5
R400 VSS.t6 VSS.n16 292.5
R401 VSS.n16 VSS.n13 292.5
R402 VSS.t3 VSS.t32 290.079
R403 VSS.t12 VSS.t5 272.846
R404 VSS.t29 VSS.n90 259.5
R405 VSS.n103 VSS.t23 259.5
R406 VSS.n109 VSS.n56 249.637
R407 VSS.n85 VSS.n78 248.454
R408 VSS.t0 VSS.t20 243.869
R409 VSS.t14 VSS.t31 241.254
R410 VSS.t16 VSS.t14 241.254
R411 VSS.t36 VSS.n115 238.679
R412 VSS.n109 VSS.n108 237.898
R413 VSS.n81 VSS.n78 237.736
R414 VSS.n106 VSS.n58 216.534
R415 VSS.n107 VSS.n106 216.534
R416 VSS.n83 VSS.t8 211.87
R417 VSS.n83 VSS.t9 211.87
R418 VSS.n95 VSS.t30 211.87
R419 VSS.t24 VSS.n61 211.87
R420 VSS.n61 VSS.t25 211.87
R421 VSS.n87 VSS.n86 210.681
R422 VSS.n87 VSS.n74 210.681
R423 VSS.n96 VSS.t10 208.585
R424 VSS.n116 VSS.n53 190.713
R425 VSS.t41 VSS.n122 180.308
R426 VSS.n123 VSS.t18 170.28
R427 VSS.n103 VSS.n102 146.25
R428 VSS.n102 VSS.n101 146.25
R429 VSS.n90 VSS.n72 146.25
R430 VSS.n72 VSS.n71 146.25
R431 VSS.n97 VSS.n96 146.25
R432 VSS.n98 VSS.n97 146.25
R433 VSS.n53 VSS.n52 146.25
R434 VSS.n52 VSS.n51 146.25
R435 VSS.n124 VSS.n123 146.25
R436 VSS.n125 VSS.n124 146.25
R437 VSS.n37 VSS.n34 146.25
R438 VSS.n38 VSS.n37 146.25
R439 VSS.n31 VSS.n26 146.25
R440 VSS.n32 VSS.n31 146.25
R441 VSS.n27 VSS.n25 146.25
R442 VSS.n27 VSS.n21 146.25
R443 VSS.t4 VSS.t0 145.284
R444 VSS.n51 VSS.n50 138.183
R445 VSS.n71 VSS.n64 138.166
R446 VSS.n101 VSS.n100 138.166
R447 VSS.t2 VSS.t4 128.421
R448 VSS.t18 VSS.t2 118.043
R449 VSS.n125 VSS.n14 117.778
R450 VSS.t39 VSS.t42 111.558
R451 VSS.t42 VSS.t44 111.558
R452 VSS.t44 VSS.t45 111.558
R453 VSS.t20 VSS.t41 108.963
R454 VSS.n116 VSS.t39 107.665
R455 VSS.n93 VSS.n70 98.6537
R456 VSS.n65 VSS.n57 98.6537
R457 VSS.n90 VSS.n89 90.3327
R458 VSS.n104 VSS.n103 90.3327
R459 VSS.n51 VSS.n20 85.5375
R460 VSS.n99 VSS.n98 82.6519
R461 VSS.n44 VSS.n32 78.6829
R462 VSS.n32 VSS.n22 78.6829
R463 VSS.n38 VSS.n36 78.6829
R464 VSS.n39 VSS.n38 78.6829
R465 VSS.n98 VSS.n3 76.4348
R466 VSS.n83 VSS.n82 65.0005
R467 VSS.n82 VSS.n81 65.0005
R468 VSS.n95 VSS.n94 65.0005
R469 VSS.n94 VSS.n3 65.0005
R470 VSS.n61 VSS.n54 65.0005
R471 VSS.n108 VSS.n54 65.0005
R472 VSS.n61 VSS.n55 65.0005
R473 VSS.n56 VSS.n55 65.0005
R474 VSS.n95 VSS.n68 65.0005
R475 VSS.n76 VSS.n68 65.0005
R476 VSS.n84 VSS.n83 65.0005
R477 VSS.n85 VSS.n84 65.0005
R478 VSS.n39 VSS.n14 59.4829
R479 VSS.n40 VSS.n39 59.4829
R480 VSS.n40 VSS.n22 59.4829
R481 VSS.n48 VSS.n22 59.4829
R482 VSS.n49 VSS.n48 59.4829
R483 VSS.n50 VSS.n49 59.4829
R484 VSS.n49 VSS.n21 58.2963
R485 VSS.n100 VSS.n99 53.0829
R486 VSS.n99 VSS.n64 53.0829
R487 VSS.t10 VSS.t23 52.5574
R488 VSS.t29 VSS.t30 44.3454
R489 VSS.n111 VSS.n110 36.563
R490 VSS.n110 VSS.n109 36.563
R491 VSS.n80 VSS.n79 36.563
R492 VSS.n79 VSS.n78 36.563
R493 VSS.n89 VSS.n88 36.563
R494 VSS.n88 VSS.n87 36.563
R495 VSS.n105 VSS.n104 36.563
R496 VSS.n106 VSS.n105 36.563
R497 VSS.n2 VSS 1.72683
R498 VSS.t19 VSS.n0 5.08971
R499 VSS.n4 VSS.t15 38.2073
R500 VSS.n5 VSS.t17 32.4046
R501 VSS.n113 VSS.n10 31.3427
R502 VSS.t40 VSS.n7 30.4369
R503 VSS.t43 VSS.n8 28.3642
R504 VSS.t21 VSS.n2 28.3575
R505 VSS.n0 VSS.t13 30.4107
R506 VSS.n9 VSS.t46 23.9
R507 VSS.n71 VSS.n70 18.0711
R508 VSS.n101 VSS.n57 18.0711
R509 VSS.n58 VSS.n56 18.0171
R510 VSS.n126 VSS.t7 17.926
R511 VSS.n86 VSS.n85 17.8722
R512 VSS.n3 VSS.n65 16.1529
R513 VSS.n119 VSS.n118 14.8179
R514 VSS.n115 VSS.n11 1202.37
R515 VSS.n30 VSS.t27 14.4208
R516 VSS.n86 VSS.n77 11.0626
R517 VSS.n3 VSS.n93 16.0513
R518 VSS.n75 VSS.t11 9.55388
R519 VSS.n127 VSS.n12 9.5505
R520 VSS.n11 VSS 2.58917
R521 VSS.n118 VSS.n7 5.21334
R522 VSS VSS.n7 2.04483
R523 VSS.n8 VSS.t40 5.02305
R524 VSS.n8 VSS 2.13997
R525 VSS.t43 VSS.n9 5.45298
R526 VSS VSS.n9 1.92501
R527 VSS.n10 VSS.t46 5.60763
R528 VSS.n10 VSS 1.84768
R529 VSS.n113 VSS 9.3005
R530 VSS VSS.n114 9.3005
R531 VSS VSS.n119 9.3005
R532 VSS.n120 VSS 9.3005
R533 VSS.n6 VSS 1.95183
R534 VSS.n5 VSS 1.62567
R535 VSS VSS.n4 1.73611
R536 VSS.n4 VSS.t13 5.83079
R537 VSS.t1 VSS.n2 4.26202
R538 VSS.n127 VSS.n126 9.3005
R539 VSS.n76 VSS.n75 9.22616
R540 VSS.n75 VSS.n58 8.79144
R541 VSS.n45 VSS.n30 8.38942
R542 VSS.n108 VSS.n107 8.3038
R543 VSS.n6 VSS.t17 13.6817
R544 VSS.n81 VSS.n74 8.23702
R545 VSS.n121 VSS.t21 6.49593
R546 VSS.n36 VSS.n13 6.22327
R547 VSS.n44 VSS.n43 6.22327
R548 VSS.n45 VSS.n44 6.22327
R549 VSS.n120 VSS.t34 5.98311
R550 VSS.n114 VSS.t37 5.98311
R551 VSS.n43 VSS.n12 5.1205
R552 VSS.t48 VSS.n120 4.8005
R553 VSS.n114 VSS.t47 4.8005
R554 VSS.n30 VSS.n20 4.05712
R555 VSS.n1 VSS.t11 4.01612
R556 VSS.n1 VSS.n127 3.97967
R557 VSS.n77 VSS.n76 3.58653
R558 VSS.n96 VSS.n95 3.28531
R559 VSS.n77 VSS.t11 3.11691
R560 VSS.t27 VSS.n21 2.51189
R561 VSS.t7 VSS.n125 2.51189
R562 VSS.t15 VSS.n5 8.31048
R563 VSS.t35 VSS.t48 1.18311
R564 VSS.t47 VSS.t38 1.18311
R565 VSS.n36 VSS.n12 1.10327
R566 VSS.n74 VSS.n70 0.890935
R567 VSS.n107 VSS.n57 0.824152
R568 VSS.n126 VSS.n13 0.551885
R569 VSS.n6 VSS.t35 5.81674
R570 VSS.n119 VSS.t34 0.417891
R571 VSS.t38 VSS.n113 0.417891
R572 VSS.n11 VSS.t37 4.54204
R573 VSS.n121 VSS 1.57208
R574 VSS VSS.n0 1.17831
R575 VSS VSS.n1 1.09461
R576 x4.Y.n2 x4.Y.t15 1043.42
R577 x4.Y.n3 x4.Y.t16 1043.42
R578 x4.Y.n2 x4.Y.t13 1043.25
R579 x4.Y.n3 x4.Y.t18 1043.25
R580 x4.Y.n1 x4.Y.t12 1038.91
R581 x4.Y.n0 x4.Y.t19 1038.91
R582 x4.Y.n1 x4.Y.t14 1038.54
R583 x4.Y.n0 x4.Y.t17 1038.54
R584 x4.Y.n15 x4.Y.n10 312.226
R585 x4.Y.n14 x4.Y.n11 312.226
R586 x4.Y.n13 x4.Y.n12 311.849
R587 x4.Y.n5 x4.Y.t10 214.587
R588 x4.Y.n5 x4.Y.t11 214.587
R589 x4.Y.n17 x4.Y.n8 203.322
R590 x4.Y.n16 x4.Y.n9 202.97
R591 x4.Y.n16 x4.Y.n15 137.036
R592 x4.Y.n18 x4.Y.n17 51.9534
R593 x4.Y.n15 x4.Y.n14 45.5534
R594 x4.Y.n14 x4.Y.n13 45.177
R595 x4.Y.n17 x4.Y.n16 45.177
R596 x4.Y.n9 x4.Y.t0 40.0005
R597 x4.Y.n9 x4.Y.t1 40.0005
R598 x4.Y.n8 x4.Y.t2 40.0005
R599 x4.Y.n8 x4.Y.t3 40.0005
R600 x4.Y.n12 x4.Y.t8 27.5805
R601 x4.Y.n12 x4.Y.t9 27.5805
R602 x4.Y.n11 x4.Y.t6 27.5805
R603 x4.Y.n11 x4.Y.t7 27.5805
R604 x4.Y.n10 x4.Y.t4 27.5805
R605 x4.Y.n10 x4.Y.t5 27.5805
R606 x4.Y.n13 x4.Y 23.4672
R607 x4.Y.n7 x4.Y 21.2288
R608 x4.Y x4.Y.n18 12.5872
R609 x4.Y x4.Y.n7 10.8805
R610 x4.Y x4.Y.n6 8.97312
R611 x4.Y.n6 x4.Y.n5 8.22323
R612 x4.Y.n6 x4.Y.n4 7.91176
R613 x4.Y.n1 x4.Y.n2 5.898
R614 x4.Y.n0 x4.Y.n3 5.898
R615 x4.Y x4.Y.n7 3.62717
R616 x4.Y.n18 x4.Y 1.9205
R617 x4.Y.n4 x4.Y.n0 1.19112
R618 x4.Y.n4 x4.Y.n1 1.17863
R619 a_65_4595.n2 a_65_4595.t2 443.44
R620 a_65_4595.t1 a_65_4595.n5 390.067
R621 a_65_4595.n3 a_65_4595.t3 345.305
R622 a_65_4595.n3 a_65_4595.t6 296.969
R623 a_65_4595.n1 a_65_4595.t0 287.998
R624 a_65_4595.n0 a_65_4595.t7 263.173
R625 a_65_4595.n2 a_65_4595.t4 254.389
R626 a_65_4595.n0 a_65_4595.t5 227.826
R627 a_65_4595.n4 a_65_4595.n2 193.59
R628 a_65_4595.n1 a_65_4595.n0 152
R629 a_65_4595.n5 a_65_4595.n1 35.3396
R630 a_65_4595.n4 a_65_4595.n3 12.4401
R631 a_65_4595.n5 a_65_4595.n4 11.0742
C0 a_419_4595# x3.D 0.12345f
C1 a_1570_n470# VINN 0.7501f
C2 a_624_n1752# x4.Y 0.74231f
C3 a_231_4595# a_672_4707# 0.12805f
C4 x2.VLAT_PLUS a_881_2436# 0.31507f
C5 a_624_n1752# VINP 0.65494f
C6 x4.Y CLK 0.77533f
C7 a_932_2929# a_881_2436# 0.3501f
C8 a_1097_4863# COMP_OUT 0.19239f
C9 a_932_2929# a_1561_2214# 0.17077f
C10 x2.VLAT_PLUS x4.Y 2.16251f
C11 a_366_n1752# a_624_n1752# 1.15167f
C12 a_624_n1752# VINN 0.65468f
C13 a_1570_n470# x2.VLAT_MINUS 0.85021f
C14 a_366_n1752# x4.Y 0.73241f
C15 a_929_2214# a_881_2436# 0.34901f
C16 a_231_4595# x3.D 0.23046f
C17 a_929_2214# a_1561_2214# 0.17079f
C18 a_366_n1752# x2.VLAT_PLUS 0.53944f
C19 a_366_n1752# VINP 0.75123f
C20 a_1570_n470# a_624_n1752# 1.07677f
C21 x2.VLAT_MINUS a_1561_2214# 0.33021f
C22 a_624_n1752# x2.VLAT_MINUS 0.13604f
C23 a_1097_4863# a_929_4961# 0.31086f
C24 a_929_2214# x2.VLAT_PLUS 0.22271f
C25 x3.D a_1561_2214# 0.21045f
C26 COMP_OUT CLK 0.20424f
C27 a_1570_n470# x4.Y 0.60943f
C28 x4.Y x2.VLAT_MINUS 1.13659f
C29 a_231_4595# a_929_4961# 0.19701f
C30 x2.VLAT_PLUS x2.VLAT_MINUS 0.98953f
C31 x3.D x4.Y 1.39332f
C32 a_419_4595# a_231_4595# 0.10323f
C33 a_504_4961# a_672_4707# 0.23992f
C34 COMP_OUT VSS 0.70687f
C35 a_624_n1752# VSS 5.13624f
C36 a_1570_n470# VSS 3.25709f
C37 a_366_n1752# VSS 3.13011f
C38 a_929_2214# VSS 4.87381f
C39 a_881_2436# VSS 1.79573f
C40 x4.Y VSS 13.0628f
C41 a_1013_4961# VSS 0.20153f
C42 a_599_4961# VSS 0.17536f
C43 a_419_4595# VSS 2.09398f
C44 a_672_4707# VSS 0.26959f
C45 a_65_4595.n0 VSS 0.15304f
C46 a_65_4595.n1 VSS 0.24537f
C47 a_65_4595.n2 VSS 0.19869f
C48 a_65_4595.n3 VSS 0.36075f
C49 a_65_4595.n4 VSS 0.58133f
C50 a_65_4595.n5 VSS 0.22902f
C51 a_65_4595.t1 VSS 0.12224f
C52 x4.Y.n0 VSS 0.42093f
C53 x4.Y.n1 VSS 0.41958f
C54 x4.Y.n2 VSS 0.81272f
C55 x4.Y.n3 VSS 0.81272f
C56 x4.Y.n4 VSS 0.21244f
C57 x4.Y.n5 VSS 0.57387f
C58 x4.Y.n6 VSS 1.28338f
C59 x4.Y.n7 VSS 2.49187f
C60 x4.Y.t4 VSS 0.99216f
C61 VSS.t11 VSS 0.77923f
C62 VSS.t27 VSS 1.06527f
C63 VSS.t19 VSS 0.2624f
C64 VSS.t1 VSS 1.22196f
C65 VSS.t7 VSS 0.27679f
C66 VDD.n0 VSS 8.63476f
C67 VDD.n2 VSS 0.13763f
C68 VDD.n5 VSS 0.4907f
C69 VDD.n6 VSS 0.24031f
C70 VDD.t47 VSS 1.03061f
C71 VDD.t42 VSS 0.1566f
C72 VDD.n17 VSS 0.11401f
C73 VDD.t18 VSS 0.11075f
C74 VDD.t14 VSS 0.22923f
C75 VDD.t26 VSS 0.18737f
C76 VDD.t1 VSS 0.55856f
C77 VDD.t16 VSS 0.18928f
C78 VDD.n22 VSS 0.10487f
C79 VDD.t20 VSS 0.12525f
C80 VDD.n25 VSS 0.13836f
C81 VDD.n26 VSS 0.16136f
C82 VDD.n32 VSS 0.16136f
C83 VDD.n40 VSS 0.16136f
C84 VDD.t31 VSS 0.34525f
C85 VDD.n45 VSS 0.13836f
C86 VDD.t30 VSS 0.18144f
C87 VDD.t32 VSS 0.16136f
C88 VDD.t28 VSS 0.16136f
C89 VDD.t6 VSS 0.18144f
C90 VDD.n71 VSS 0.10415f
C91 VDD.t11 VSS 0.6972f
C92 VDD.t10 VSS 0.27149f
C93 VDD.t41 VSS 0.27149f
C94 VDD.n81 VSS 0.17557f
C95 VDD.t5 VSS 0.69955f
C96 VDD.n82 VSS 0.27336f
C97 VDD.t24 VSS 0.60076f
C98 VDD.n88 VSS 0.27795f
C99 VDD.t4 VSS 0.27149f
C100 VDD.t23 VSS 0.27149f
C101 VDD.t40 VSS 0.39508f
C102 VDD.n98 VSS 0.36775f
C103 VDD.t39 VSS 0.30347f
C104 VDD.n104 VSS 0.41887f
C105 VDD.t19 VSS 0.27149f
C106 VDD.n105 VSS 0.12411f
C107 VDD.n112 VSS 0.12411f
C108 VDD.n121 VSS 0.14234f
C109 VDD.t29 VSS 0.10924f
C110 VDD.n122 VSS 0.27795f
C111 VDD.n123 VSS 0.17109f
C112 VDD.t33 VSS 0.10924f
C113 VDD.n124 VSS 0.14234f
C114 VDD.n126 VSS 0.44561f
C115 VDD.t34 VSS 0.59583f
C116 VDD.n130 VSS 0.12411f
C117 VDD.n136 VSS 0.41887f
C118 VDD.t12 VSS 0.27149f
C119 VDD.n137 VSS 0.12411f
C120 VDD.t8 VSS 0.30347f
C121 VDD.n138 VSS 0.36751f
C122 VDD.t9 VSS 1.15426f
.ends
