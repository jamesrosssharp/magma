* NGSPICE file created from high_speed_comp_top_routed.ext - technology: sky130A

.subckt high_speed_comp_top_routed VINP VINN VDD VSS CLK COMP_OUT
X0 a_504_4961# a_231_4595# a_419_4595# VDD.t2 sky130_fd_pr__pfet_01v8_hvt ad=0.06825 pd=0.745 as=0.05775 ps=0.695 w=0.42 l=0.15
X1 VDD.t26 a_672_4707# a_599_4961# VDD.t25 sky130_fd_pr__pfet_01v8_hvt ad=0.17887 pd=1.26 as=0.07665 ps=0.785 w=0.42 l=0.15
X2 a_929_2214# a_881_2436# VSS.t7 VSS.t6 sky130_fd_pr__nfet_01v8 ad=0.29 pd=2.58 as=0.29 ps=2.58 w=1 l=0.15
X3 a_929_4961# a_65_4595.t4 a_672_4707# VDD.t27 sky130_fd_pr__pfet_01v8_hvt ad=0.0567 pd=0.69 as=0.1095 ps=1.075 w=0.42 l=0.15
X4 VDD.t14 a_1097_4863# a_1013_4961# VDD.t13 sky130_fd_pr__pfet_01v8_hvt ad=0.1113 pd=1.37 as=0.0882 ps=0.84 w=0.42 l=0.15
X5 a_929_4961# a_231_4595# a_672_4707# VSS.t3 sky130_fd_pr__special_nfet_01v8 ad=0.0684 pd=0.74 as=0.0989 ps=0.995 w=0.36 l=0.15
X6 x3.D a_1561_2214# VDD.t31 VDD.t30 sky130_fd_pr__pfet_01v8 ad=0.29 pd=2.58 as=0.29 ps=2.58 w=1 l=0.15
X7 x2.VLAT_PLUS x4.Y.t17 VDD.t11 VDD.t10 sky130_fd_pr__pfet_01v8 ad=0.825 pd=5.33 as=1.55 ps=10.62 w=5 l=0.15
X8 a_231_4595# a_65_4595.t5 VSS.t21 VSS.t20 sky130_fd_pr__nfet_01v8 ad=0.1092 pd=1.36 as=0.0567 ps=0.69 w=0.42 l=0.15
X9 a_1561_2214# x2.VLAT_MINUS a_929_2214# VSS.t28 sky130_fd_pr__nfet_01v8 ad=0.29 pd=2.58 as=0.29 ps=2.58 w=1 l=0.15
X10 COMP_OUT a_1097_4863# VDD.t16 VDD.t15 sky130_fd_pr__pfet_01v8_hvt ad=0.135 pd=1.27 as=0.135 ps=1.27 w=1 l=0.15
X11 x4.Y.t4 CLK VDD.t47 VDD.t46 sky130_fd_pr__pfet_01v8_hvt ad=0.14 pd=1.28 as=0.305 ps=2.61 w=1 l=0.15
X12 VDD.t50 CLK x4.Y.t7 VDD.t49 sky130_fd_pr__pfet_01v8_hvt ad=0.14 pd=1.28 as=0.14 ps=1.28 w=1 l=0.15
X13 COMP_OUT a_1097_4863# VSS.t15 VSS.t14 sky130_fd_pr__nfet_01v8 ad=0.08775 pd=0.92 as=0.08775 ps=0.92 w=0.65 l=0.15
X14 VDD.t38 CLK a_65_4595.t1 VDD.t48 sky130_fd_pr__pfet_01v8_hvt ad=0.0864 pd=0.91 as=0.1664 ps=1.8 w=0.64 l=0.15
X15 x4.Y.t8 CLK VDD.t50 VDD.t54 sky130_fd_pr__pfet_01v8_hvt ad=0.14 pd=1.28 as=0.14 ps=1.28 w=1 l=0.15
X16 VSS.t35 VDD.t58 VSS.t34 VSS.t33 sky130_fd_pr__nfet_01v8 ad=0.143 pd=1.62 as=0 ps=0 w=0.55 l=0.59
X17 x2.VLAT_MINUS x4.Y.t15 VDD.t24 VDD.t23 sky130_fd_pr__pfet_01v8 ad=0.825 pd=5.33 as=1.55 ps=10.62 w=5 l=0.15
X18 VDD.t5 x4.Y.t14 x2.VLAT_MINUS VDD.t4 sky130_fd_pr__pfet_01v8 ad=1.55 pd=10.62 as=0.825 ps=5.33 w=5 l=0.15
X19 VDD.t52 CLK x4.Y.t5 VDD.t51 sky130_fd_pr__pfet_01v8_hvt ad=0.14 pd=1.28 as=0.14 ps=1.28 w=1 l=0.15
X20 a_932_2929# a_881_2436# VDD.t7 VDD.t6 sky130_fd_pr__pfet_01v8 ad=0.29 pd=2.58 as=0.29 ps=2.58 w=1 l=0.15
X21 a_1570_n470# x4.Y.t13 VDD.t5 VDD.t19 sky130_fd_pr__pfet_01v8 ad=0.825 pd=5.33 as=1.55 ps=10.62 w=5 l=0.15
X22 VDD.t16 a_929_4961# a_1097_4863# VDD.t36 sky130_fd_pr__pfet_01v8_hvt ad=0.135 pd=1.27 as=0.27 ps=2.54 w=1 l=0.15
X23 VDD.t40 x4.Y.t12 a_1570_n470# VDD.t39 sky130_fd_pr__pfet_01v8 ad=1.55 pd=10.62 as=0.825 ps=5.33 w=5 l=0.15
X24 VDD.t56 CLK x4.Y.t9 VDD.t55 sky130_fd_pr__pfet_01v8_hvt ad=0.345 pd=2.69 as=0.14 ps=1.28 w=1 l=0.15
X25 VSS.t15 a_929_4961# a_1097_4863# VSS.t31 sky130_fd_pr__nfet_01v8 ad=0.08775 pd=0.92 as=0.169 ps=1.82 w=0.65 l=0.15
X26 VSS.t38 VDD.t57 VSS.t37 VSS.t36 sky130_fd_pr__nfet_01v8 ad=0.143 pd=1.62 as=0 ps=0 w=0.55 l=0.59
X27 a_504_4961# a_65_4595.t3 a_419_4595# VSS.t4 sky130_fd_pr__special_nfet_01v8 ad=0.0621 pd=0.705 as=0.0813 ps=0.83 w=0.36 l=0.15
X28 VSS.t19 a_672_4707# a_630_4595# VSS.t18 sky130_fd_pr__nfet_01v8 ad=0.12095 pd=1.085 as=0.0696 ps=0.765 w=0.42 l=0.15
X29 x4.Y.t6 CLK VDD.t52 VDD.t53 sky130_fd_pr__pfet_01v8_hvt ad=0.14 pd=1.28 as=0.14 ps=1.28 w=1 l=0.15
X30 a_1561_2214# x2.VLAT_MINUS a_932_2929# VDD.t32 sky130_fd_pr__pfet_01v8 ad=0.29 pd=2.58 as=0.29 ps=2.58 w=1 l=0.15
X31 VSS.t11 x4.Y.t11 a_624_n1752# VSS.t30 sky130_fd_pr__nfet_01v8_lvt ad=0.725 pd=5.29 as=1.45 ps=10.58 w=5 l=1
X32 a_419_4595# x3.D VSS.t1 VSS.t0 sky130_fd_pr__nfet_01v8 ad=0.0813 pd=0.83 as=0.1092 ps=1.36 w=0.42 l=0.15
X33 a_630_4595# a_231_4595# a_504_4961# VSS.t2 sky130_fd_pr__special_nfet_01v8 ad=0.0696 pd=0.765 as=0.0621 ps=0.705 w=0.36 l=0.15
X34 a_929_2214# x2.VLAT_PLUS a_881_2436# VSS.t22 sky130_fd_pr__nfet_01v8 ad=0.29 pd=2.58 as=0.29 ps=2.58 w=1 l=0.15
X35 x2.VLAT_PLUS x2.VLAT_MINUS VDD.t34 VDD.t33 sky130_fd_pr__pfet_01v8 ad=0.29 pd=2.58 as=0.29 ps=2.58 w=1 l=0.15
X36 VDD.t22 VSS.t48 VDD.t21 VDD.t20 sky130_fd_pr__pfet_01v8_hvt ad=0.2262 pd=2.26 as=0 ps=0 w=0.87 l=0.59
X37 a_624_n1752# VINN a_1570_n470# VSS.t24 sky130_fd_pr__nfet_01v8_lvt ad=0.725 pd=5.29 as=1.45 ps=10.58 w=5 l=1
X38 VSS.t21 CLK a_65_4595.t0 VSS.t41 sky130_fd_pr__nfet_01v8 ad=0.0567 pd=0.69 as=0.1092 ps=1.36 w=0.42 l=0.15
X39 VDD.t18 a_1097_4863# COMP_OUT VDD.t17 sky130_fd_pr__pfet_01v8_hvt ad=0.26 pd=2.52 as=0.135 ps=1.27 w=1 l=0.15
X40 VSS.t17 a_1097_4863# COMP_OUT VSS.t16 sky130_fd_pr__nfet_01v8 ad=0.169 pd=1.82 as=0.08775 ps=0.92 w=0.65 l=0.15
X41 a_366_n1752# x4.Y.t19 VDD.t9 VDD.t8 sky130_fd_pr__pfet_01v8 ad=0.825 pd=5.33 as=1.55 ps=10.62 w=5 l=0.15
X42 x2.VLAT_PLUS x2.VLAT_MINUS a_366_n1752# VSS.t29 sky130_fd_pr__nfet_01v8 ad=0.29 pd=2.58 as=0.29 ps=2.58 w=1 l=0.15
X43 a_672_4707# a_504_4961# VSS.t19 VSS.t32 sky130_fd_pr__nfet_01v8 ad=0.0989 pd=0.995 as=0.12095 ps=1.085 w=0.64 l=0.15
X44 a_1055_4595# a_65_4595.t2 a_929_4961# VSS.t5 sky130_fd_pr__special_nfet_01v8 ad=0.066 pd=0.745 as=0.0684 ps=0.74 w=0.36 l=0.15
X45 VSS.t13 a_1097_4863# a_1055_4595# VSS.t12 sky130_fd_pr__nfet_01v8 ad=0.1092 pd=1.36 as=0.066 ps=0.745 w=0.42 l=0.15
X46 x3.D a_1561_2214# VSS.t27 VSS.t26 sky130_fd_pr__nfet_01v8 ad=0.29 pd=2.58 as=0.29 ps=2.58 w=1 l=0.15
X47 VDD.t11 x4.Y.t18 a_366_n1752# VDD.t12 sky130_fd_pr__pfet_01v8 ad=1.55 pd=10.62 as=0.825 ps=5.33 w=5 l=0.15
X48 VDD.t44 VSS.t47 VDD.t43 VDD.t42 sky130_fd_pr__pfet_01v8_hvt ad=0.2262 pd=2.26 as=0 ps=0 w=0.87 l=0.59
X49 a_1570_n470# VINN a_624_n1752# VSS.t25 sky130_fd_pr__nfet_01v8_lvt ad=1.45 pd=10.58 as=0.725 ps=5.29 w=5 l=1
X50 a_419_4595# x3.D VDD.t1 VDD.t0 sky130_fd_pr__pfet_01v8_hvt ad=0.05775 pd=0.695 as=0.1092 ps=1.36 w=0.42 l=0.15
X51 a_1013_4961# a_231_4595# a_929_4961# VDD.t3 sky130_fd_pr__pfet_01v8_hvt ad=0.0882 pd=0.84 as=0.0567 ps=0.69 w=0.42 l=0.15
X52 a_599_4961# a_65_4595.t6 a_504_4961# VDD.t35 sky130_fd_pr__pfet_01v8_hvt ad=0.07665 pd=0.785 as=0.06825 ps=0.745 w=0.42 l=0.15
X53 a_932_2929# x2.VLAT_PLUS a_881_2436# VDD.t28 sky130_fd_pr__pfet_01v8 ad=0.29 pd=2.58 as=0.29 ps=2.58 w=1 l=0.15
X54 a_624_n1752# x4.Y.t10 VSS.t11 VSS.t10 sky130_fd_pr__nfet_01v8_lvt ad=1.45 pd=10.58 as=0.725 ps=5.29 w=5 l=1
X55 x4.Y.t2 CLK VSS.t43 VSS.t44 sky130_fd_pr__nfet_01v8 ad=0.0588 pd=0.7 as=0.0588 ps=0.7 w=0.42 l=0.15
X56 VDD.t24 x2.VLAT_PLUS x2.VLAT_MINUS VDD.t29 sky130_fd_pr__pfet_01v8 ad=0.29 pd=2.58 as=0.29 ps=2.58 w=1 l=0.15
X57 a_672_4707# a_504_4961# VDD.t26 VDD.t45 sky130_fd_pr__pfet_01v8_hvt ad=0.1095 pd=1.075 as=0.17887 ps=1.26 w=0.75 l=0.15
X58 VSS.t46 CLK x4.Y.t3 VSS.t45 sky130_fd_pr__nfet_01v8 ad=0.1659 pd=1.63 as=0.0588 ps=0.7 w=0.42 l=0.15
X59 a_1570_n470# x2.VLAT_PLUS x2.VLAT_MINUS VSS.t23 sky130_fd_pr__nfet_01v8 ad=0.29 pd=2.58 as=0.29 ps=2.58 w=1 l=0.15
X60 a_231_4595# a_65_4595.t7 VDD.t38 VDD.t37 sky130_fd_pr__pfet_01v8_hvt ad=0.1664 pd=1.8 as=0.0864 ps=0.91 w=0.64 l=0.15
X61 x4.Y.t0 CLK VSS.t40 VSS.t39 sky130_fd_pr__nfet_01v8 ad=0.0588 pd=0.7 as=0.1386 ps=1.5 w=0.42 l=0.15
X62 VDD.t34 x4.Y.t16 x2.VLAT_PLUS VDD.t41 sky130_fd_pr__pfet_01v8 ad=1.55 pd=10.62 as=0.825 ps=5.33 w=5 l=0.15
X63 a_366_n1752# VINP a_624_n1752# VSS.t9 sky130_fd_pr__nfet_01v8_lvt ad=1.45 pd=10.58 as=0.725 ps=5.29 w=5 l=1
X64 a_624_n1752# VINP a_366_n1752# VSS.t8 sky130_fd_pr__nfet_01v8_lvt ad=0.725 pd=5.29 as=1.45 ps=10.58 w=5 l=1
X65 VSS.t43 CLK x4.Y.t1 VSS.t42 sky130_fd_pr__nfet_01v8 ad=0.0588 pd=0.7 as=0.0588 ps=0.7 w=0.42 l=0.15
R0 VDD.n139 VDD.n74 3031.76
R1 VDD.n139 VDD.n73 3031.76
R2 VDD.n130 VDD.n80 3031.76
R3 VDD.n101 VDD.n98 3031.76
R4 VDD.n106 VDD.n98 3031.76
R5 VDD.n111 VDD.n83 3031.76
R6 VDD.n136 VDD.n76 2290.59
R7 VDD.n136 VDD.n75 2290.59
R8 VDD.n103 VDD.n94 2290.59
R9 VDD.n103 VDD.n95 2290.59
R10 VDD.n84 VDD.n79 1510.59
R11 VDD.n91 VDD.n86 1510.59
R12 VDD.n68 VDD.n24 1312.94
R13 VDD.n50 VDD.n44 1312.94
R14 VDD.n132 VDD.n79 1238.82
R15 VDD.n113 VDD.n91 1238.82
R16 VDD.n16 VDD.t42 761.744
R17 VDD.n92 VDD.n89 755.294
R18 VDD.n89 VDD.n87 755.294
R19 VDD.n27 VDD.n26 755.294
R20 VDD.n27 VDD.n23 755.294
R21 VDD.n41 VDD.n40 755.294
R22 VDD.n41 VDD.n38 755.294
R23 VDD.n35 VDD.n30 755.294
R24 VDD.n35 VDD.n32 755.294
R25 VDD.n76 VDD.n74 741.178
R26 VDD.n132 VDD.n76 741.178
R27 VDD.n75 VDD.n73 741.178
R28 VDD.n130 VDD.n75 741.178
R29 VDD.n113 VDD.n94 741.178
R30 VDD.n101 VDD.n94 741.178
R31 VDD.n111 VDD.n95 741.178
R32 VDD.n106 VDD.n95 741.178
R33 VDD.t17 VDD.t20 739.875
R34 VDD.t42 VDD.t55 736.917
R35 VDD.t13 VDD.t36 621.495
R36 VDD.n85 VDD.n84 557.648
R37 VDD.n87 VDD.n85 557.648
R38 VDD.n125 VDD.n87 557.648
R39 VDD.n125 VDD.n86 557.648
R40 VDD.n90 VDD.n79 557.648
R41 VDD.n92 VDD.n90 557.648
R42 VDD.n120 VDD.n92 557.648
R43 VDD.n120 VDD.n91 557.648
R44 VDD.n66 VDD.n26 557.648
R45 VDD.n61 VDD.n26 557.648
R46 VDD.n61 VDD.n30 557.648
R47 VDD.n54 VDD.n30 557.648
R48 VDD.n54 VDD.n40 557.648
R49 VDD.n50 VDD.n40 557.648
R50 VDD.n68 VDD.n23 557.648
R51 VDD.n60 VDD.n23 557.648
R52 VDD.n60 VDD.n32 557.648
R53 VDD.n55 VDD.n32 557.648
R54 VDD.n55 VDD.n38 557.648
R55 VDD.n48 VDD.n38 557.648
R56 VDD.t37 VDD.t0 556.386
R57 VDD.t20 VDD.n21 544.548
R58 VDD.n14 VDD.n13 528.84
R59 VDD.n115 VDD.n14 528.84
R60 VDD.n21 VDD.t46 440.966
R61 VDD.t25 VDD.t45 390.654
R62 VDD.t29 VDD.n121 352.187
R63 VDD.n124 VDD.t33 352.187
R64 VDD.t3 VDD.t13 337.384
R65 VDD.n100 VDD.n99 323.526
R66 VDD.n140 VDD.n72 323.389
R67 VDD.t35 VDD.t25 304.829
R68 VDD.t2 VDD.t35 281.154
R69 VDD.t45 VDD.t27 281.154
R70 VDD.t6 VDD.n25 264.262
R71 VDD.t28 VDD.n25 264.262
R72 VDD.t28 VDD.n31 264.262
R73 VDD.t32 VDD.n31 264.262
R74 VDD.t32 VDD.n39 264.262
R75 VDD.t30 VDD.n39 264.262
R76 VDD.t51 VDD.t46 254.518
R77 VDD.t53 VDD.t51 254.518
R78 VDD.t49 VDD.t53 254.518
R79 VDD.t54 VDD.t49 254.518
R80 VDD.t55 VDD.t54 254.518
R81 VDD.t0 VDD.t2 251.559
R82 VDD.n99 VDD.n97 251.405
R83 VDD.n141 VDD.n140 250.345
R84 VDD.t48 VDD.t37 248.599
R85 VDD.t27 VDD.t3 248.599
R86 VDD.t36 VDD.t15 248.599
R87 VDD.t15 VDD.t17 248.599
R88 VDD.n135 VDD.n134 244.329
R89 VDD.n102 VDD.n93 244.329
R90 VDD.n135 VDD.n78 242.825
R91 VDD.n102 VDD.n96 242.825
R92 VDD.n67 VDD.n24 237.584
R93 VDD.n49 VDD.n44 237.584
R94 VDD.n21 VDD.n20 213.119
R95 VDD.n51 VDD.n43 139.976
R96 VDD.n115 VDD.n114 132.142
R97 VDD.n133 VDD.n13 132.142
R98 VDD.n65 VDD.n64 121.138
R99 VDD.n139 VDD.t8 117.906
R100 VDD.t39 VDD.n98 117.906
R101 VDD.t12 VDD.n137 107.025
R102 VDD.n137 VDD.t10 107.025
R103 VDD.n122 VDD.t41 107.025
R104 VDD.t23 VDD.n88 107.025
R105 VDD.n104 VDD.t4 107.025
R106 VDD.t19 VDD.n104 107.025
R107 VDD.n121 VDD.n90 92.5005
R108 VDD.n117 VDD.n90 92.5005
R109 VDD.n121 VDD.n120 92.5005
R110 VDD.n120 VDD.n119 92.5005
R111 VDD.n125 VDD.n124 92.5005
R112 VDD.n14 VDD.n125 92.5005
R113 VDD.n124 VDD.n85 92.5005
R114 VDD.n14 VDD.n85 92.5005
R115 VDD.n68 VDD.t6 92.5005
R116 VDD.n69 VDD.n68 92.5005
R117 VDD.t28 VDD.n60 92.5005
R118 VDD.n60 VDD.n59 92.5005
R119 VDD.n55 VDD.t32 92.5005
R120 VDD.n56 VDD.n55 92.5005
R121 VDD.n48 VDD.n47 92.5005
R122 VDD.n50 VDD.t30 92.5005
R123 VDD.n51 VDD.n50 92.5005
R124 VDD.t32 VDD.n54 92.5005
R125 VDD.n54 VDD.n53 92.5005
R126 VDD.n61 VDD.t28 92.5005
R127 VDD.n62 VDD.n61 92.5005
R128 VDD.n66 VDD.n65 92.5005
R129 VDD.n45 VDD.n43 83.2475
R130 VDD.n118 VDD.n116 80.5652
R131 VDD.n116 VDD.n14 80.5652
R132 VDD.n36 VDD.n29 80.5652
R133 VDD.n37 VDD.n36 80.5652
R134 VDD.n63 VDD.n28 80.5652
R135 VDD.n33 VDD.n28 80.5652
R136 VDD.n114 VDD.n93 79.0593
R137 VDD.n100 VDD.n93 79.0593
R138 VDD.n134 VDD.n72 79.0593
R139 VDD.n134 VDD.n133 79.0593
R140 VDD.n67 VDD.n66 70.7763
R141 VDD.n49 VDD.n48 70.7763
R142 VDD.n123 VDD.t29 65.0195
R143 VDD.t33 VDD.n123 65.0195
R144 VDD.n52 VDD.n42 61.6559
R145 VDD.n117 VDD.n13 59.4829
R146 VDD.n118 VDD.n117 59.4829
R147 VDD.n119 VDD.n118 59.4829
R148 VDD.n119 VDD.n115 59.4829
R149 VDD.n65 VDD.n63 59.4829
R150 VDD.n63 VDD.n62 59.4829
R151 VDD.n62 VDD.n29 59.4829
R152 VDD.n53 VDD.n29 59.4829
R153 VDD.n53 VDD.n52 59.4829
R154 VDD.n52 VDD.n51 59.4829
R155 VDD.n106 VDD.n105 46.2505
R156 VDD.n107 VDD.n106 46.2505
R157 VDD.n112 VDD.n111 46.2505
R158 VDD.n111 VDD.n110 46.2505
R159 VDD.n113 VDD.n112 46.2505
R160 VDD.n114 VDD.n113 46.2505
R161 VDD.n105 VDD.n101 46.2505
R162 VDD.n101 VDD.n100 46.2505
R163 VDD.n123 VDD.n89 46.2505
R164 VDD.n116 VDD.n89 46.2505
R165 VDD.n132 VDD.n131 46.2505
R166 VDD.n133 VDD.n132 46.2505
R167 VDD.n138 VDD.n74 46.2505
R168 VDD.n74 VDD.n72 46.2505
R169 VDD.n138 VDD.n73 46.2505
R170 VDD.n73 VDD.n71 46.2505
R171 VDD.n131 VDD.n130 46.2505
R172 VDD.n130 VDD.n129 46.2505
R173 VDD.n44 VDD.n43 46.2505
R174 VDD.n64 VDD.n24 46.2505
R175 VDD.n27 VDD.n25 46.2505
R176 VDD.n28 VDD.n27 46.2505
R177 VDD.n41 VDD.n39 46.2505
R178 VDD.n42 VDD.n41 46.2505
R179 VDD.n35 VDD.n31 46.2505
R180 VDD.n36 VDD.n35 46.2505
R181 VDD.n84 VDD.n80 42.3534
R182 VDD.n86 VDD.n83 42.3534
R183 VDD.n123 VDD.n122 35.0144
R184 VDD.n123 VDD.n88 35.0144
R185 VDD.n5 VDD.n3 47.4632
R186 VDD.t8 VDD.n138 31.7112
R187 VDD.n138 VDD.t12 31.7112
R188 VDD.n131 VDD.t10 31.7112
R189 VDD.n131 VDD.t41 31.7112
R190 VDD.n112 VDD.t23 31.7112
R191 VDD.n112 VDD.t4 31.7112
R192 VDD.n105 VDD.t19 31.7112
R193 VDD.n105 VDD.t39 31.7112
R194 VDD.t16 VDD.n6 37.4011
R195 VDD.n12 VDD.t50 32.9936
R196 VDD.n10 VDD.t52 5.38743
R197 VDD.n7 VDD.t18 31.6517
R198 VDD.t52 VDD.n11 29.036
R199 VDD.t48 VDD.n0 631.112
R200 VDD.n1 VDD.t38 5.04016
R201 VDD.t1 VDD.n1 5.54548
R202 VDD.n11 VDD.t50 4.94188
R203 VDD.n10 VDD.t47 24.9639
R204 VDD.t30 VDD.n49 16.7394
R205 VDD.t6 VDD.n67 16.7394
R206 VDD.n12 VDD.t56 4.38186
R207 VDD.t26 VDD.n3 11.6008
R208 VDD.n5 VDD.t14 21.1105
R209 VDD.n70 VDD.t7 14.4208
R210 VDD.t31 VDD.n34 14.4208
R211 VDD.t56 VDD.n18 14.2735
R212 VDD.n20 VDD.t21 14.2735
R213 VDD.n110 VDD.n96 13.8562
R214 VDD.n129 VDD.n78 13.8562
R215 VDD.n127 VDD.n126 13.5861
R216 VDD.n108 VDD.n107 13.3283
R217 VDD.n77 VDD.n71 13.2624
R218 VDD.n9 VDD.t47 3.79208
R219 VDD.n99 VDD.n98 11.0403
R220 VDD.n122 VDD.n80 10.8829
R221 VDD.n126 VDD.n80 10.8829
R222 VDD.n88 VDD.n83 10.8829
R223 VDD.n126 VDD.n83 10.8829
R224 VDD.n140 VDD.n139 10.8829
R225 VDD.n137 VDD.n136 10.8829
R226 VDD.n136 VDD.n135 10.8829
R227 VDD.n104 VDD.n103 10.8829
R228 VDD.n103 VDD.n102 10.8829
R229 VDD.n0 VDD.n70 10.5356
R230 VDD.n45 VDD.n0 9.5505
R231 VDD.n128 VDD.t34 9.3005
R232 VDD.n77 VDD.t11 9.3005
R233 VDD.t9 VDD.n141 9.3005
R234 VDD.n97 VDD.t40 9.3005
R235 VDD.t5 VDD.n108 9.3005
R236 VDD.n109 VDD.t24 9.3005
R237 VDD.n22 VDD.n0 9.3005
R238 VDD.n58 VDD.n0 9.3005
R239 VDD.n0 VDD.n15 9.3005
R240 VDD.n0 VDD.n57 9.3005
R241 VDD.n46 VDD.n0 9.3005
R242 VDD.n2 VDD.n5 1.62567
R243 VDD.n6 VDD.t14 5.77756
R244 VDD.n6 VDD.n2 1.76272
R245 VDD.n2 VDD.n7 1.62567
R246 VDD.n8 VDD.n2 1.97608
R247 VDD.n4 VDD.n19 9.3005
R248 VDD.n4 VDD.t21 9.3005
R249 VDD.n20 VDD.n9 3.79208
R250 VDD.n4 VDD.n9 2.75546
R251 VDD.n10 VDD.n4 1.95779
R252 VDD.n4 VDD.n11 2.18056
R253 VDD.n12 VDD.n4 2.46057
R254 VDD.n18 VDD.n4 9.3005
R255 VDD.n4 VDD.n17 9.3005
R256 VDD.n8 VDD.t18 14.3861
R257 VDD.n109 VDD.n81 7.45617
R258 VDD.n128 VDD.n81 7.39019
R259 VDD.n57 VDD.n34 6.77477
R260 VDD.n107 VDD.n97 6.33452
R261 VDD.n141 VDD.n71 6.33452
R262 VDD.n56 VDD.n37 5.91395
R263 VDD.n59 VDD.n15 5.53968
R264 VDD.n110 VDD.n109 5.27885
R265 VDD.n129 VDD.n128 5.21287
R266 VDD.n82 VDD.n127 4.53781
R267 VDD.n17 VDD.t44 4.36875
R268 VDD.n19 VDD.t22 4.36875
R269 VDD.n47 VDD.n45 4.34202
R270 VDD.t43 VDD.n16 4.32903
R271 VDD.n58 VDD.n33 3.96775
R272 VDD.n70 VDD.n69 3.85547
R273 VDD.n33 VDD.n22 3.51863
R274 VDD.n17 VDD.t57 3.50526
R275 VDD.n19 VDD.t58 3.50526
R276 VDD.n47 VDD.n46 3.14436
R277 VDD.n7 VDD.t16 9.06342
R278 VDD.n64 VDD.t7 2.91696
R279 VDD.n42 VDD.t31 2.91696
R280 VDD.n4 VDD.n16 2.77604
R281 VDD.n69 VDD.n22 2.39582
R282 VDD.n59 VDD.n58 1.9467
R283 VDD.n0 VDD.t9 1.29581
R284 VDD.n57 VDD.n56 1.19816
R285 VDD.t58 VDD.t21 1.16875
R286 VDD.t57 VDD.t43 0.863992
R287 VDD.n46 VDD.n34 0.711611
R288 VDD.n126 VDD.n14 0.671159
R289 VDD.n127 VDD.n81 0.632835
R290 VDD.n78 VDD.n77 0.594314
R291 VDD.t34 VDD.n82 0.555508
R292 VDD.t24 VDD.n82 0.555508
R293 VDD.n108 VDD.n96 0.528335
R294 VDD.t5 VDD.t40 0.466125
R295 VDD.t34 VDD.t11 0.466125
R296 VDD.t24 VDD.t5 0.466125
R297 VDD.t9 VDD.t11 0.464563
R298 VDD.n37 VDD.n15 0.374769
R299 VDD.n18 VDD.t44 0.305262
R300 VDD.t22 VDD.n8 5.6556
R301 VDD.n0 VDD.n3 1.83318
R302 VDD.n0 VDD.n2 1.7842
R303 VDD.n4 VDD.n2 1.67758
R304 VDD.n1 VDD.n0 1.31015
R305 VSS.n114 VSS.n19 24836
R306 VSS.n82 VSS.n19 6156.29
R307 VSS.n114 VSS.n113 6073.79
R308 VSS.n86 VSS.n81 5684.03
R309 VSS.n84 VSS.n81 5684.03
R310 VSS.n112 VSS.n56 5684.03
R311 VSS.n112 VSS.n57 5684.03
R312 VSS.n107 VSS.n62 3425.61
R313 VSS.n107 VSS.n61 3425.61
R314 VSS.n90 VSS.n75 3333.03
R315 VSS.n90 VSS.n71 3333.03
R316 VSS.n123 VSS.n18 2126.44
R317 VSS.n123 VSS.n17 2126.44
R318 VSS.n54 VSS.n21 2126.44
R319 VSS.n54 VSS.n20 2126.44
R320 VSS.n93 VSS.n74 2126.44
R321 VSS.n94 VSS.n74 2126.44
R322 VSS.n104 VSS.n64 2126.44
R323 VSS.n104 VSS.n65 2126.44
R324 VSS.n61 VSS.n56 2056.91
R325 VSS.n96 VSS.n61 2056.91
R326 VSS.n70 VSS.n62 2056.91
R327 VSS.n62 VSS.n57 2056.91
R328 VSS.n96 VSS.n71 2039.53
R329 VSS.n75 VSS.n70 2039.53
R330 VSS.n86 VSS.n75 2039.53
R331 VSS.n84 VSS.n71 2039.53
R332 VSS.n99 VSS.n69 1272.06
R333 VSS.n99 VSS.n68 1272.06
R334 VSS.n30 VSS.n29 1210.97
R335 VSS.n29 VSS.n25 1210.97
R336 VSS.n33 VSS.n31 1210.97
R337 VSS.n33 VSS.n26 1210.97
R338 VSS.n39 VSS.n35 1210.97
R339 VSS.n39 VSS.n37 1210.97
R340 VSS.n121 VSS.n120 1205.01
R341 VSS.n119 VSS.n118 1198.25
R342 VSS.n116 VSS.n13 1202.37
R343 VSS.n35 VSS.n18 915.471
R344 VSS.n44 VSS.n35 915.471
R345 VSS.n44 VSS.n31 915.471
R346 VSS.n48 VSS.n31 915.471
R347 VSS.n48 VSS.n30 915.471
R348 VSS.n30 VSS.n21 915.471
R349 VSS.n37 VSS.n17 915.471
R350 VSS.n43 VSS.n37 915.471
R351 VSS.n43 VSS.n26 915.471
R352 VSS.n49 VSS.n26 915.471
R353 VSS.n49 VSS.n25 915.471
R354 VSS.n25 VSS.n20 915.471
R355 VSS.n68 VSS.n64 816.971
R356 VSS.n93 VSS.n68 816.971
R357 VSS.n94 VSS.n69 816.971
R358 VSS.n69 VSS.n65 816.971
R359 VSS.t33 VSS.t16 712.273
R360 VSS.n121 VSS.n19 587.619
R361 VSS.t31 VSS.t12 542.821
R362 VSS.n122 VSS.t6 538.082
R363 VSS.n36 VSS.t6 538.082
R364 VSS.t22 VSS.n36 538.082
R365 VSS.t22 VSS.n28 538.082
R366 VSS.t28 VSS.n28 538.082
R367 VSS.t28 VSS.n27 538.082
R368 VSS.n27 VSS.t26 538.082
R369 VSS.n55 VSS.t26 538.082
R370 VSS.n118 VSS.t33 528.46
R371 VSS.n118 VSS.n117 436.555
R372 VSS.t45 VSS.t36 434.553
R373 VSS.n116 VSS.n114 406.014
R374 VSS.t8 VSS.n82 399.104
R375 VSS.n91 VSS.t9 399.104
R376 VSS.n106 VSS.t24 399.104
R377 VSS.n113 VSS.t25 399.104
R378 VSS.t18 VSS.t32 364.752
R379 VSS.t5 VSS.t3 304.44
R380 VSS.t29 VSS.n93 292.5
R381 VSS.n93 VSS.n66 292.5
R382 VSS.n64 VSS.t23 292.5
R383 VSS.n102 VSS.n64 292.5
R384 VSS.n65 VSS.t23 292.5
R385 VSS.n67 VSS.n65 292.5
R386 VSS.n94 VSS.t29 292.5
R387 VSS.n95 VSS.n94 292.5
R388 VSS.t6 VSS.n17 292.5
R389 VSS.n17 VSS.n16 292.5
R390 VSS.t22 VSS.n43 292.5
R391 VSS.n43 VSS.n42 292.5
R392 VSS.n49 VSS.t28 292.5
R393 VSS.n50 VSS.n49 292.5
R394 VSS.n20 VSS.t26 292.5
R395 VSS.n52 VSS.n20 292.5
R396 VSS.n21 VSS.t26 292.5
R397 VSS.n22 VSS.n21 292.5
R398 VSS.t28 VSS.n48 292.5
R399 VSS.n48 VSS.n47 292.5
R400 VSS.n44 VSS.t22 292.5
R401 VSS.n45 VSS.n44 292.5
R402 VSS.t6 VSS.n18 292.5
R403 VSS.n18 VSS.n15 292.5
R404 VSS.t3 VSS.t32 290.079
R405 VSS.t12 VSS.t5 272.846
R406 VSS.t29 VSS.n92 259.5
R407 VSS.n105 VSS.t23 259.5
R408 VSS.n111 VSS.n58 249.637
R409 VSS.n87 VSS.n80 248.454
R410 VSS.t0 VSS.t20 243.869
R411 VSS.t14 VSS.t31 241.254
R412 VSS.t16 VSS.t14 241.254
R413 VSS.t36 VSS.n116 238.679
R414 VSS.n111 VSS.n110 237.898
R415 VSS.n83 VSS.n80 237.736
R416 VSS.n108 VSS.n60 216.534
R417 VSS.n109 VSS.n108 216.534
R418 VSS.n85 VSS.t8 211.87
R419 VSS.n85 VSS.t9 211.87
R420 VSS.n97 VSS.t30 211.87
R421 VSS.t24 VSS.n63 211.87
R422 VSS.n63 VSS.t25 211.87
R423 VSS.n89 VSS.n88 210.681
R424 VSS.n89 VSS.n76 210.681
R425 VSS.n98 VSS.t10 208.585
R426 VSS.n117 VSS.n55 190.713
R427 VSS.t41 VSS.n121 180.308
R428 VSS.n122 VSS.t18 170.28
R429 VSS.n105 VSS.n104 146.25
R430 VSS.n104 VSS.n103 146.25
R431 VSS.n92 VSS.n74 146.25
R432 VSS.n74 VSS.n73 146.25
R433 VSS.n99 VSS.n98 146.25
R434 VSS.n100 VSS.n99 146.25
R435 VSS.n55 VSS.n54 146.25
R436 VSS.n54 VSS.n53 146.25
R437 VSS.n123 VSS.n122 146.25
R438 VSS.n124 VSS.n123 146.25
R439 VSS.n39 VSS.n36 146.25
R440 VSS.n40 VSS.n39 146.25
R441 VSS.n33 VSS.n28 146.25
R442 VSS.n34 VSS.n33 146.25
R443 VSS.n29 VSS.n27 146.25
R444 VSS.n29 VSS.n23 146.25
R445 VSS.t4 VSS.t0 145.284
R446 VSS.n53 VSS.n52 138.183
R447 VSS.n73 VSS.n66 138.166
R448 VSS.n103 VSS.n102 138.166
R449 VSS.t2 VSS.t4 128.421
R450 VSS.t18 VSS.t2 118.043
R451 VSS.n124 VSS.n16 117.778
R452 VSS.t39 VSS.t42 111.558
R453 VSS.t42 VSS.t44 111.558
R454 VSS.t44 VSS.t45 111.558
R455 VSS.t20 VSS.t41 108.963
R456 VSS.n117 VSS.t39 107.665
R457 VSS.n95 VSS.n72 98.6537
R458 VSS.n67 VSS.n59 98.6537
R459 VSS.n92 VSS.n91 90.3327
R460 VSS.n106 VSS.n105 90.3327
R461 VSS.n53 VSS.n22 85.5375
R462 VSS.n101 VSS.n100 82.6519
R463 VSS.n46 VSS.n34 78.6829
R464 VSS.n34 VSS.n24 78.6829
R465 VSS.n40 VSS.n38 78.6829
R466 VSS.n41 VSS.n40 78.6829
R467 VSS.n100 VSS.n7 76.4348
R468 VSS.n85 VSS.n84 65.0005
R469 VSS.n84 VSS.n83 65.0005
R470 VSS.n97 VSS.n96 65.0005
R471 VSS.n96 VSS.n7 65.0005
R472 VSS.n63 VSS.n56 65.0005
R473 VSS.n110 VSS.n56 65.0005
R474 VSS.n63 VSS.n57 65.0005
R475 VSS.n58 VSS.n57 65.0005
R476 VSS.n97 VSS.n70 65.0005
R477 VSS.n78 VSS.n70 65.0005
R478 VSS.n86 VSS.n85 65.0005
R479 VSS.n87 VSS.n86 65.0005
R480 VSS.n41 VSS.n16 59.4829
R481 VSS.n42 VSS.n41 59.4829
R482 VSS.n42 VSS.n24 59.4829
R483 VSS.n50 VSS.n24 59.4829
R484 VSS.n51 VSS.n50 59.4829
R485 VSS.n52 VSS.n51 59.4829
R486 VSS.n51 VSS.n23 58.2963
R487 VSS.n102 VSS.n101 53.0829
R488 VSS.n101 VSS.n66 53.0829
R489 VSS.t10 VSS.t23 52.5574
R490 VSS.t29 VSS.t30 44.3454
R491 VSS.n113 VSS.n112 36.563
R492 VSS.n112 VSS.n111 36.563
R493 VSS.n82 VSS.n81 36.563
R494 VSS.n81 VSS.n80 36.563
R495 VSS.n91 VSS.n90 36.563
R496 VSS.n90 VSS.n89 36.563
R497 VSS.n107 VSS.n106 36.563
R498 VSS.n108 VSS.n107 36.563
R499 VSS.n6 VSS.n0 1.72683
R500 VSS.n0 VSS.n2 0.960167
R501 VSS.n3 VSS.t15 38.4787
R502 VSS.n0 VSS.t19 4.99299
R503 VSS.n8 VSS.t17 32.4046
R504 VSS.t38 VSS.n4 6.86112
R505 VSS.t40 VSS.n10 30.4369
R506 VSS.t43 VSS.n11 28.3642
R507 VSS.t21 VSS.n6 28.3575
R508 VSS.n2 VSS.n3 1.38502
R509 VSS.n12 VSS.t46 23.9
R510 VSS.n73 VSS.n72 18.0711
R511 VSS.n103 VSS.n59 18.0711
R512 VSS.n60 VSS.n58 18.0171
R513 VSS.n125 VSS.t7 17.926
R514 VSS.n88 VSS.n87 17.8722
R515 VSS.n7 VSS.n67 16.1529
R516 VSS.t34 VSS.n119 14.8179
R517 VSS.n13 VSS.t37 4.54204
R518 VSS.n32 VSS.t27 14.4208
R519 VSS.n88 VSS.n79 11.0626
R520 VSS.n7 VSS.n95 16.0513
R521 VSS.n77 VSS.t11 9.55388
R522 VSS.n126 VSS.n14 9.5505
R523 VSS.n13 VSS.n1 2.58917
R524 VSS.n119 VSS.n10 5.21334
R525 VSS.n2 VSS.n10 2.04483
R526 VSS.n11 VSS.t40 5.02305
R527 VSS.n11 VSS.n2 2.13997
R528 VSS.t43 VSS.n12 5.45298
R529 VSS.n1 VSS.n12 1.92501
R530 VSS.n4 VSS.t46 6.9707
R531 VSS.n1 VSS.n115 9.3005
R532 VSS.n5 VSS.t34 2.3818
R533 VSS.n5 VSS.n2 3.4606
R534 VSS.n9 VSS.n2 1.95183
R535 VSS.n8 VSS.n2 1.62567
R536 VSS.n3 VSS.t13 4.65022
R537 VSS.t1 VSS.n6 4.26202
R538 VSS.n126 VSS.n125 9.3005
R539 VSS.n78 VSS.n77 9.22616
R540 VSS.n77 VSS.n60 8.79144
R541 VSS.n47 VSS.n32 8.38942
R542 VSS.n110 VSS.n109 8.3038
R543 VSS.n9 VSS.t17 13.6817
R544 VSS.n83 VSS.n76 8.23702
R545 VSS.n120 VSS.t21 6.49493
R546 VSS.n38 VSS.n15 6.22327
R547 VSS.n46 VSS.n45 6.22327
R548 VSS.n47 VSS.n46 6.22327
R549 VSS.n115 VSS.t37 5.98311
R550 VSS.n45 VSS.n14 5.1205
R551 VSS.n115 VSS.t47 4.8005
R552 VSS.n32 VSS.n22 4.05712
R553 VSS.n1 VSS.t11 4.01612
R554 VSS.n1 VSS.n126 3.97967
R555 VSS.n79 VSS.n78 3.58653
R556 VSS.n98 VSS.n97 3.28531
R557 VSS.n79 VSS.t11 3.11691
R558 VSS.t27 VSS.n23 2.51189
R559 VSS.t7 VSS.n124 2.51189
R560 VSS.t15 VSS.n8 8.31048
R561 VSS.t48 VSS.n5 7.1818
R562 VSS.t35 VSS.t48 1.18311
R563 VSS.n38 VSS.n14 1.10327
R564 VSS.n76 VSS.n72 0.890935
R565 VSS.n109 VSS.n59 0.824152
R566 VSS.n125 VSS.n15 0.551885
R567 VSS.n9 VSS.t35 5.81674
R568 VSS.n2 VSS.n1 1.91717
R569 VSS.t47 VSS.t38 1.6005
R570 VSS.n120 VSS.n0 1.05239
R571 VSS.n4 VSS.n1 1.04119
R572 x4.Y.n2 x4.Y.t15 1043.42
R573 x4.Y.n3 x4.Y.t16 1043.42
R574 x4.Y.n2 x4.Y.t13 1043.25
R575 x4.Y.n3 x4.Y.t18 1043.25
R576 x4.Y.n1 x4.Y.t12 1038.91
R577 x4.Y.n0 x4.Y.t19 1038.91
R578 x4.Y.n1 x4.Y.t14 1038.54
R579 x4.Y.n0 x4.Y.t17 1038.54
R580 x4.Y.n15 x4.Y.n10 312.226
R581 x4.Y.n14 x4.Y.n11 312.226
R582 x4.Y.n13 x4.Y.n12 311.849
R583 x4.Y.n5 x4.Y.t10 214.587
R584 x4.Y.n5 x4.Y.t11 214.587
R585 x4.Y.n17 x4.Y.n8 203.322
R586 x4.Y.n16 x4.Y.n9 202.97
R587 x4.Y.n16 x4.Y.n15 137.036
R588 x4.Y.n18 x4.Y.n17 51.9534
R589 x4.Y.n15 x4.Y.n14 45.5534
R590 x4.Y.n14 x4.Y.n13 45.177
R591 x4.Y.n17 x4.Y.n16 45.177
R592 x4.Y.n9 x4.Y.t0 40.0005
R593 x4.Y.n9 x4.Y.t1 40.0005
R594 x4.Y.n8 x4.Y.t2 40.0005
R595 x4.Y.n8 x4.Y.t3 40.0005
R596 x4.Y.n12 x4.Y.t8 27.5805
R597 x4.Y.n12 x4.Y.t9 27.5805
R598 x4.Y.n11 x4.Y.t6 27.5805
R599 x4.Y.n11 x4.Y.t7 27.5805
R600 x4.Y.n10 x4.Y.t4 27.5805
R601 x4.Y.n10 x4.Y.t5 27.5805
R602 x4.Y.n13 x4.Y 23.4672
R603 x4.Y.n7 x4.Y 21.2288
R604 x4.Y x4.Y.n18 12.5872
R605 x4.Y x4.Y.n7 10.8805
R606 x4.Y x4.Y.n6 8.97312
R607 x4.Y.n6 x4.Y.n5 8.22323
R608 x4.Y.n6 x4.Y.n4 7.91176
R609 x4.Y.n1 x4.Y.n2 5.898
R610 x4.Y.n0 x4.Y.n3 5.898
R611 x4.Y x4.Y.n7 3.62717
R612 x4.Y.n18 x4.Y 1.9205
R613 x4.Y.n4 x4.Y.n0 1.19112
R614 x4.Y.n4 x4.Y.n1 1.17863
R615 a_65_4595.n2 a_65_4595.t2 443.44
R616 a_65_4595.t1 a_65_4595.n5 390.067
R617 a_65_4595.n3 a_65_4595.t3 345.305
R618 a_65_4595.n3 a_65_4595.t6 296.969
R619 a_65_4595.n1 a_65_4595.t0 287.998
R620 a_65_4595.n0 a_65_4595.t7 263.173
R621 a_65_4595.n2 a_65_4595.t4 254.389
R622 a_65_4595.n0 a_65_4595.t5 227.826
R623 a_65_4595.n4 a_65_4595.n2 193.59
R624 a_65_4595.n1 a_65_4595.n0 152
R625 a_65_4595.n5 a_65_4595.n1 35.3396
R626 a_65_4595.n4 a_65_4595.n3 12.4401
R627 a_65_4595.n5 a_65_4595.n4 11.0742
R628 VDD.t2 VDD 1m
R629 VSS.t6 VSS 1m
C0 x2.VLAT_MINUS a_1561_2214# 0.33021f
C1 a_624_n1752# x2.VLAT_MINUS 0.13604f
C2 a_1097_4863# a_929_4961# 0.31086f
C3 a_929_2214# x2.VLAT_PLUS 0.22271f
C4 x3.D a_1561_2214# 0.21045f
C5 COMP_OUT CLK 0.2043f
C6 a_1570_n470# x4.Y 0.60943f
C7 x4.Y x2.VLAT_MINUS 1.13659f
C8 a_231_4595# a_929_4961# 0.19718f
C9 x2.VLAT_PLUS x2.VLAT_MINUS 0.98953f
C10 x3.D x4.Y 1.39334f
C11 a_419_4595# a_231_4595# 0.1033f
C12 a_504_4961# a_672_4707# 0.23992f
C13 a_419_4595# x3.D 0.12351f
C14 a_1570_n470# VINN 0.7501f
C15 a_624_n1752# x4.Y 0.74231f
C16 a_231_4595# a_672_4707# 0.12813f
C17 x2.VLAT_PLUS a_881_2436# 0.31507f
C18 a_624_n1752# VINP 0.65494f
C19 x4.Y CLK 0.77628f
C20 a_932_2929# a_881_2436# 0.3501f
C21 a_1097_4863# COMP_OUT 0.19318f
C22 a_932_2929# a_1561_2214# 0.17077f
C23 x2.VLAT_PLUS x4.Y 2.16251f
C24 a_366_n1752# a_624_n1752# 1.15167f
C25 a_624_n1752# VINN 0.65468f
C26 a_1570_n470# x2.VLAT_MINUS 0.85021f
C27 a_366_n1752# x4.Y 0.73241f
C28 a_929_2214# a_881_2436# 0.34901f
C29 a_231_4595# x3.D 0.23058f
C30 a_929_2214# a_1561_2214# 0.17079f
C31 a_366_n1752# x2.VLAT_PLUS 0.53944f
C32 a_366_n1752# VINP 0.75123f
C33 a_1570_n470# a_624_n1752# 1.07677f
C34 COMP_OUT 0 0.69994f
C35 a_624_n1752# 0 5.13603f
C36 a_1570_n470# 0 3.25706f
C37 a_366_n1752# 0 3.13009f
C38 a_929_2214# 0 4.8738f
C39 a_881_2436# 0 1.79572f
C40 x4.Y 0 13.05578f
C41 a_1013_4961# 0 0.20111f
C42 a_599_4961# 0 0.17467f
C43 a_419_4595# 0 2.09066f
C44 a_672_4707# 0 0.26835f
C45 a_65_4595.n0 0 0.1525f
C46 a_65_4595.n1 0 0.2445f
C47 a_65_4595.n2 0 0.19799f
C48 a_65_4595.n3 0 0.35947f
C49 a_65_4595.n4 0 0.57927f
C50 a_65_4595.n5 0 0.22822f
C51 a_65_4595.t1 0 0.12181f
C52 x4.Y.n0 0 0.42082f
C53 x4.Y.n1 0 0.41947f
C54 x4.Y.n2 0 0.81251f
C55 x4.Y.n3 0 0.81251f
C56 x4.Y.n4 0 0.21238f
C57 x4.Y.n5 0 0.57372f
C58 x4.Y.n6 0 1.28305f
C59 x4.Y.n7 0 2.49123f
C60 x4.Y.t4 0 0.99167f
C61 VSS.t11 0 0.77903f
C62 VSS.t27 0 1.06526f
C63 VSS.t19 0 0.26118f
C64 VSS.t1 0 1.22041f
C65 VSS.t7 0 0.27679f
C66 VDD.n0 0 8.61973f
C67 VDD.n2 0 0.127f
C68 VDD.n4 0 0.22069f
C69 VDD.t47 0 1.0301f
C70 VDD.t42 0 0.15654f
C71 VDD.n16 0 0.11391f
C72 VDD.t18 0 0.11036f
C73 VDD.t14 0 0.22873f
C74 VDD.t26 0 0.18677f
C75 VDD.t1 0 0.55855f
C76 VDD.t16 0 0.18851f
C77 VDD.n21 0 0.10483f
C78 VDD.t20 0 0.1252f
C79 VDD.n24 0 0.13831f
C80 VDD.n25 0 0.16131f
C81 VDD.n31 0 0.16131f
C82 VDD.n39 0 0.16131f
C83 VDD.t31 0 0.34523f
C84 VDD.n44 0 0.13831f
C85 VDD.t30 0 0.18138f
C86 VDD.t32 0 0.16131f
C87 VDD.t28 0 0.16131f
C88 VDD.t6 0 0.18138f
C89 VDD.n70 0 0.10412f
C90 VDD.t11 0 0.69697f
C91 VDD.t10 0 0.27139f
C92 VDD.t41 0 0.27139f
C93 VDD.n81 0 0.17551f
C94 VDD.t5 0 0.69932f
C95 VDD.n82 0 0.27327f
C96 VDD.t24 0 0.60056f
C97 VDD.n88 0 0.27786f
C98 VDD.t4 0 0.27139f
C99 VDD.t23 0 0.27139f
C100 VDD.t40 0 0.39495f
C101 VDD.n98 0 0.36762f
C102 VDD.t39 0 0.30336f
C103 VDD.n104 0 0.41872f
C104 VDD.t19 0 0.27139f
C105 VDD.n105 0 0.12407f
C106 VDD.n112 0 0.12407f
C107 VDD.n121 0 0.14229f
C108 VDD.t29 0 0.1092f
C109 VDD.n122 0 0.27786f
C110 VDD.n123 0 0.17102f
C111 VDD.t33 0 0.1092f
C112 VDD.n124 0 0.14229f
C113 VDD.n126 0 0.44305f
C114 VDD.n127 0 0.44545f
C115 VDD.t34 0 0.59563f
C116 VDD.n131 0 0.12407f
C117 VDD.n137 0 0.41872f
C118 VDD.t12 0 0.27139f
C119 VDD.n138 0 0.12407f
C120 VDD.t8 0 0.30336f
C121 VDD.n139 0 0.36739f
C122 VDD.t9 0 1.15387f
.ends
