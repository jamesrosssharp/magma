.include /opt/pdk/sky130A/libs.ref/sky130_fd_sc_hd/spice/sky130_fd_sc_hd.spice

** sch_path: /home/jrsharp/code/magma/xschem/flash_converter/flash_converter.sch
.subckt flash_converter_routed VIN RES_TOP RES_OUT O0 O1 O2 O3 O4 O5 O6 O7 CLK VDD VSS
*.PININFO VIN:I RES_TOP:I RES_OUT:O O0:O O1:O O2:O O3:O O4:O O5:O O6:O O7:O CLK:I VDD:I VSS:I
x1 CLK VIN RES_TOP VDD O0 VSS high_speed_comp_top
x2 CLK VIN net1 VDD O1 VSS high_speed_comp_top
x3 CLK VIN net2 VDD O2 VSS high_speed_comp_top
x4 CLK VIN net3 VDD O3 VSS high_speed_comp_top
x5 CLK VIN net4 VDD O4 VSS high_speed_comp_top
x6 CLK VIN net5 VDD O5 VSS high_speed_comp_top
x7 CLK VIN net6 VDD O6 VSS high_speed_comp_top
x8 CLK VIN net7 VDD O7 VSS high_speed_comp_top
XR1 net1 RES_TOP VSS sky130_fd_pr__res_high_po_1p41 L=1.41 mult=1 m=1
XR2 net2 net1 VSS sky130_fd_pr__res_high_po_1p41 L=1.41 mult=1 m=1
XR3 net3 net2 VSS sky130_fd_pr__res_high_po_1p41 L=1.41 mult=1 m=1
XR4 net4 net3 VSS sky130_fd_pr__res_high_po_1p41 L=1.41 mult=1 m=1
XR5 net5 net4 VSS sky130_fd_pr__res_high_po_1p41 L=1.41 mult=1 m=1
XR6 net6 net5 VSS sky130_fd_pr__res_high_po_1p41 L=1.41 mult=1 m=1
XR7 net7 net6 VSS sky130_fd_pr__res_high_po_1p41 L=1.41 mult=1 m=1
XR8 RES_OUT net7 VSS sky130_fd_pr__res_high_po_1p41 L=1.41 mult=1 m=1
XR9 net8 net9 VSS sky130_fd_pr__res_high_po_1p41 L=1.41 mult=1 m=1
XR10 net10 net11 VSS sky130_fd_pr__res_high_po_1p41 L=1.41 mult=1 m=1
XR11 net12 net13 VSS sky130_fd_pr__res_high_po_1p41 L=1.41 mult=1 m=1
XR12 net14 net15 VSS sky130_fd_pr__res_high_po_1p41 L=1.41 mult=1 m=1
.ends

* expanding   symbol:  high_speed_comp_top.sym # of pins=6
** sym_path: /home/jrsharp/code/magma/xschem/flash_converter/high_speed_comp_top.sym
** sch_path: /home/jrsharp/code/magma/xschem/flash_converter/high_speed_comp_top.sch
.subckt high_speed_comp_top CLK VINP VINN VDD COMP_OUT VSS
*.PININFO VINP:I VINN:I CLK:I COMP_OUT:O VDD:I VSS:I
x1 VDD CLK_PRIME net1 net2 VSS VINP VINN strong_arm_latch
x2 VDD net1 net2 VOUT VSS post_amplifier
x3 CLK VOUT VSS VSS VDD VDD COMP_OUT sky130_fd_sc_hd__dfxtp_2
x4 CLK VSS VSS VDD VDD CLK_PRIME sky130_fd_sc_hd__clkinv_4
x5 VSS VSS VDD VDD sky130_fd_sc_hd__decap_3
x7 VSS VSS VDD VDD sky130_fd_sc_hd__decap_3
x9 VSS VDD sky130_fd_sc_hd__tapvpwrvgnd_1
x6 VSS VDD sky130_fd_sc_hd__tapvpwrvgnd_1
x8 VSS VDD sky130_fd_sc_hd__tapvpwrvgnd_1
.ends

* expanding   symbol:  strong_arm_latch.sym # of pins=7
** sym_path: /home/jrsharp/code/magma/xschem/flash_converter/strong_arm_latch.sym
** sch_path: /home/jrsharp/code/magma/xschem/flash_converter/strong_arm_latch.sch
.subckt strong_arm_latch VDD CLK VOUT_PLUS VOUT_MINUS VSS VINP VINN
*.PININFO VSS:I VDD:I CLK:I VINP:I VINN:I VOUT_MINUS:O VOUT_PLUS:O
XM1 net2 VINP net1 VSS sky130_fd_pr__nfet_01v8_lvt L=1 W=5 nf=1 m=1
XM2 net3 VINN net1 VSS sky130_fd_pr__nfet_01v8_lvt L=1 W=5 nf=1 m=1
XM3 net1 CLK VSS VSS sky130_fd_pr__nfet_01v8_lvt L=1 W=5 nf=1 m=1
XM4 VOUT_PLUS VOUT_MINUS net2 VSS sky130_fd_pr__nfet_01v8 L=0.15 W=1 nf=1 m=1
XM5 VOUT_MINUS VOUT_PLUS net3 VSS sky130_fd_pr__nfet_01v8 L=0.15 W=1 nf=1 m=1
XM6 VOUT_PLUS VOUT_MINUS VDD VDD sky130_fd_pr__pfet_01v8 L=0.15 W=1 nf=1 m=1
XM7 VOUT_MINUS VOUT_PLUS VDD VDD sky130_fd_pr__pfet_01v8 L=0.15 W=1 nf=1 m=1
XM8 VOUT_PLUS CLK VDD VDD sky130_fd_pr__pfet_01v8 L=0.15 W=10 nf=1 m=1
XM9 net2 CLK VDD VDD sky130_fd_pr__pfet_01v8 L=0.15 W=10 nf=1 m=1
XM10 VOUT_MINUS CLK VDD VDD sky130_fd_pr__pfet_01v8 L=0.15 W=10 nf=1 m=1
XM11 net3 CLK VDD VDD sky130_fd_pr__pfet_01v8 L=0.15 W=10 nf=1 m=1
.ends

* expanding   symbol:  post_amplifier.sym # of pins=5
** sym_path: /home/jrsharp/code/magma/xschem/flash_converter/post_amplifier.sym
** sch_path: /home/jrsharp/code/magma/xschem/flash_converter/post_amplifier.sch
.subckt post_amplifier VDD VLAT_PLUS VLAT_MINUS VOUT VSS
*.PININFO VLAT_PLUS:I VLAT_MINUS:I VDD:I VSS:I VOUT:O
XM1 net1 VLAT_PLUS net4 VSS sky130_fd_pr__nfet_01v8 L=0.15 W=1 nf=1 m=1
XM2 net3 VLAT_MINUS net4 VSS sky130_fd_pr__nfet_01v8 L=0.15 W=1 nf=1 m=1
XM3 net4 net1 VSS VSS sky130_fd_pr__nfet_01v8 L=0.15 W=1 nf=1 m=1
XM4 net1 VLAT_PLUS net2 VDD sky130_fd_pr__pfet_01v8 L=0.15 W=1 nf=1 m=1
XM5 net3 VLAT_MINUS net2 VDD sky130_fd_pr__pfet_01v8 L=0.15 W=1 nf=1 m=1
XM6 net2 net1 VDD VDD sky130_fd_pr__pfet_01v8 L=0.15 W=1 nf=1 m=1
XM7 VOUT net3 VSS VSS sky130_fd_pr__nfet_01v8 L=0.15 W=1 nf=1 m=1
XM8 VOUT net3 VDD VDD sky130_fd_pr__pfet_01v8 L=0.15 W=1 nf=1 m=1
.ends

.GLOBAL VSS
.end
