* NGSPICE file created from 1bit_am_routed.ext - technology: sky130A

.subckt x1bit_am_routed VDD VSS CLK VIN VOUT PWM_IN
X0 a_6395_n14501# a_6369_n14949# a_6369_n14848# VDD.t31 sky130_fd_pr__pfet_01v8_hvt ad=0.05775 pd=0.695 as=0.06825 ps=0.745 w=0.42 l=0.15
X1 XR2.R1 VSS.t5 sky130_fd_pr__cap_mim_m3_1 l=10 w=10
X2 VIN.t2 x1.VINP sky130_fd_pr__cap_mim_m3_1 l=10 w=10
X3 VSS.t58 CLK x1.x4.Y.t0 VSS.t57 sky130_fd_pr__nfet_01v8 ad=0.1386 pd=1.5 as=0.0588 ps=0.7 w=0.42 l=0.15
X4 a_6369_n15055# CLK VSS.t42 VSS.t56 sky130_fd_pr__nfet_01v8 ad=0.1092 pd=1.36 as=0.0567 ps=0.69 w=0.42 l=0.15
X5 VSS.t77 x1.x4.Y.t14 a_n114_n15681# VSS.t76 sky130_fd_pr__nfet_01v8_lvt ad=0.725 pd=5.29 as=1.45 ps=10.58 w=5 l=1
X6 VIN.t2 x1.VINP sky130_fd_pr__cap_mim_m3_1 l=10 w=10
X7 VDD.t6 VSS.t82 VDD.t5 VDD.t4 sky130_fd_pr__pfet_01v8_hvt ad=0.2262 pd=2.26 as=0 ps=0 w=0.87 l=0.59
X8 XR7.R1 XR1.R1 VSS.t48 sky130_fd_pr__res_xhigh_po_0p35 l=30
X9 a_6395_n14501# a_6369_n15055# a_6369_n14848# VSS.t43 sky130_fd_pr__special_nfet_01v8 ad=0.0813 pd=0.83 as=0.0621 ps=0.705 w=0.36 l=0.15
X10 VDD.t1 x1.x4.Y.t17 x1.x2.VLAT_PLUS VDD.t52 sky130_fd_pr__pfet_01v8 ad=1.55 pd=10.62 as=0.825 ps=5.33 w=5 l=0.15
X11 a_4729_n15534# x1.x2.VLAT_MINUS a_3988_n15877# VDD.t2 sky130_fd_pr__pfet_01v8 ad=0.29 pd=2.58 as=0.29 ps=2.58 w=1 l=0.15
X12 XR2.R1 VSS.t3 sky130_fd_pr__cap_mim_m3_1 l=10 w=10
X13 x1.x2.VLAT_PLUS x1.x4.Y.t16 VDD.t1 VDD.t52 sky130_fd_pr__pfet_01v8 ad=0.825 pd=5.33 as=1.55 ps=10.62 w=5 l=0.15
X14 VIN.t3 x1.VINP sky130_fd_pr__cap_mim_m3_1 l=10 w=10
X15 VIN.t3 x1.VINP sky130_fd_pr__cap_mim_m3_1 l=10 w=10
X16 a_6369_n14848# a_6369_n14949# a_6395_n14699# VSS.t52 sky130_fd_pr__special_nfet_01v8 ad=0.0621 pd=0.705 as=0.0696 ps=0.765 w=0.36 l=0.15
X17 VDD.t3 a_3988_n14929# a_4729_n15534# VDD.t2 sky130_fd_pr__pfet_01v8 ad=0.29 pd=2.58 as=0.29 ps=2.58 w=1 l=0.15
X18 XR2.R1 VSS.t5 sky130_fd_pr__cap_mim_m3_1 l=10 w=10
X19 VDD.t25 x1.x4.Y.t11 a_n52_n16427# VDD.t24 sky130_fd_pr__pfet_01v8 ad=1.55 pd=10.62 as=0.825 ps=5.33 w=5 l=0.15
X20 VDD.t1 x1.x2.VLAT_MINUS x1.x2.VLAT_PLUS VDD.t0 sky130_fd_pr__pfet_01v8 ad=0.29 pd=2.58 as=0.29 ps=2.58 w=1 l=0.15
X21 VIN.t3 x1.VINP sky130_fd_pr__cap_mim_m3_1 l=10 w=10
X22 VDD.t25 x1.x4.Y.t13 x1.x2.VLAT_MINUS VDD.t24 sky130_fd_pr__pfet_01v8 ad=1.55 pd=10.62 as=0.825 ps=5.33 w=5 l=0.15
X23 VSS.t39 a_6369_n14848# a_6369_n14729# VSS.t50 sky130_fd_pr__nfet_01v8 ad=0.12095 pd=1.085 as=0.0989 ps=0.995 w=0.64 l=0.15
X24 VIN.t1 x1.VINP sky130_fd_pr__cap_mim_m3_1 l=10 w=10
X25 x1.x4.Y.t9 CLK VDD.t51 VDD.t50 sky130_fd_pr__pfet_01v8_hvt ad=0.14 pd=1.28 as=0.345 ps=2.69 w=1 l=0.15
X26 x1.x2.VLAT_MINUS x1.x4.Y.t12 VDD.t25 VDD.t24 sky130_fd_pr__pfet_01v8 ad=0.825 pd=5.33 as=1.55 ps=10.62 w=5 l=0.15
X27 XR2.R1 VSS.t5 sky130_fd_pr__cap_mim_m3_1 l=10 w=10
X28 VDD.t30 VSS.t85 VDD.t29 VDD.t28 sky130_fd_pr__pfet_01v8_hvt ad=0.2262 pd=2.26 as=0 ps=0 w=0.87 l=0.59
X29 a_n52_n16427# XR2.R1 a_n114_n15681# VSS.t2 sky130_fd_pr__nfet_01v8_lvt ad=1.45 pd=10.58 as=0.725 ps=5.29 w=5 l=1
X30 XR2.R1 VSS.t5 sky130_fd_pr__cap_mim_m3_1 l=10 w=10
X31 x1.x4.Y.t7 CLK VDD.t48 VDD.t47 sky130_fd_pr__pfet_01v8_hvt ad=0.14 pd=1.28 as=0.14 ps=1.28 w=1 l=0.15
X32 XR2.R1 VSS.t5 sky130_fd_pr__cap_mim_m3_1 l=10 w=10
X33 x1.x4.Y.t5 CLK VDD.t45 VDD.t44 sky130_fd_pr__pfet_01v8_hvt ad=0.14 pd=1.28 as=0.14 ps=1.28 w=1 l=0.15
X34 a_6369_n14729# a_6369_n14949# a_6369_n15339# VSS.t53 sky130_fd_pr__special_nfet_01v8 ad=0.0989 pd=0.995 as=0.0684 ps=0.74 w=0.36 l=0.15
X35 VSS.t66 VDD.t63 VSS.t65 VSS.t64 sky130_fd_pr__nfet_01v8 ad=0.143 pd=1.62 as=0 ps=0 w=0.55 l=0.59
X36 XR2.R1 VSS.t5 sky130_fd_pr__cap_mim_m3_1 l=10 w=10
X37 XR2.R1 VSS.t3 sky130_fd_pr__cap_mim_m3_1 l=10 w=10
X38 VSS.t30 a_6369_n15507# VOUT VSS.t31 sky130_fd_pr__nfet_01v8 ad=0.08775 pd=0.92 as=0.08775 ps=0.92 w=0.65 l=0.15
X39 a_n114_n15681# x1.VINP a_n52_n14940# VSS.t2 sky130_fd_pr__nfet_01v8_lvt ad=0.725 pd=5.29 as=1.45 ps=10.58 w=5 l=1
X40 a_6369_n15339# a_6369_n15055# a_6395_n15120# VSS.t44 sky130_fd_pr__special_nfet_01v8 ad=0.0684 pd=0.74 as=0.066 ps=0.745 w=0.36 l=0.15
X41 XR2.R1 VSS.t3 sky130_fd_pr__cap_mim_m3_1 l=10 w=10
X42 x1.x4.Y.t1 CLK VSS.t60 VSS.t59 sky130_fd_pr__nfet_01v8 ad=0.0588 pd=0.7 as=0.0588 ps=0.7 w=0.42 l=0.15
X43 a_6369_n15507# a_6369_n15339# VSS.t30 VSS.t29 sky130_fd_pr__nfet_01v8 ad=0.169 pd=1.82 as=0.08775 ps=0.92 w=0.65 l=0.15
X44 x1.x2.VLAT_MINUS x1.x2.VLAT_PLUS VDD.t25 VDD.t26 sky130_fd_pr__pfet_01v8 ad=0.29 pd=2.58 as=0.29 ps=2.58 w=1 l=0.15
X45 x1.VINP XR3.R1 VSS.t45 sky130_fd_pr__res_xhigh_po_0p35 l=20
X46 a_n114_n15681# x1.x4.Y.t15 VSS.t77 VSS.t76 sky130_fd_pr__nfet_01v8_lvt ad=1.45 pd=10.58 as=0.725 ps=5.29 w=5 l=1
X47 XR2.R1 VSS.t5 sky130_fd_pr__cap_mim_m3_1 l=10 w=10
X48 a_n52_n16427# x1.x4.Y.t10 VDD.t25 VDD.t24 sky130_fd_pr__pfet_01v8 ad=0.825 pd=5.33 as=1.55 ps=10.62 w=5 l=0.15
X49 XR2.R1 VSS.t5 sky130_fd_pr__cap_mim_m3_1 l=10 w=10
X50 VDD.t20 a_6369_n15055# a_6369_n14949# VDD.t19 sky130_fd_pr__pfet_01v8_hvt ad=0.0864 pd=0.91 as=0.1664 ps=1.8 w=0.64 l=0.15
X51 VDD.t35 VSS.t83 VDD.t34 VDD.t33 sky130_fd_pr__pfet_01v8_hvt ad=0.2262 pd=2.26 as=0 ps=0 w=0.87 l=0.59
X52 a_6395_n14699# a_6369_n14729# VSS.t39 VSS.t38 sky130_fd_pr__nfet_01v8 ad=0.0696 pd=0.765 as=0.12095 ps=1.085 w=0.42 l=0.15
X53 a_n52_n14940# x1.VINP a_n114_n15681# VSS.t2 sky130_fd_pr__nfet_01v8_lvt ad=1.45 pd=10.58 as=0.725 ps=5.29 w=5 l=1
X54 XR2.R1 VSS.t5 sky130_fd_pr__cap_mim_m3_1 l=10 w=10
X55 VSS.t25 a_3988_n14929# a_4014_n15531# VSS.t1 sky130_fd_pr__nfet_01v8 ad=0.29 pd=2.58 as=0.29 ps=2.58 w=1 l=0.15
X56 XR8.R1 XR7.R1 VSS.t51 sky130_fd_pr__res_xhigh_po_0p35 l=30
X57 a_6369_n15055# CLK VDD.t20 VDD.t41 sky130_fd_pr__pfet_01v8_hvt ad=0.1664 pd=1.8 as=0.0864 ps=0.91 w=0.64 l=0.15
X58 VIN.t0 x1.VINP sky130_fd_pr__cap_mim_m3_1 l=10 w=10
X59 XR2.R1 VSS.t5 sky130_fd_pr__cap_mim_m3_1 l=10 w=10
X60 XR5.R1 x1.VINP VSS.t46 sky130_fd_pr__res_xhigh_po_0p35 l=20
X61 XR2.R1 VSS.t3 sky130_fd_pr__cap_mim_m3_1 l=10 w=10
X62 VSS.t47 a_3988_n15877# x1.x3.D VSS.t1 sky130_fd_pr__nfet_01v8 ad=0.29 pd=2.58 as=0.29 ps=2.58 w=1 l=0.15
X63 XR2.R1 VSS.t5 sky130_fd_pr__cap_mim_m3_1 l=10 w=10
X64 VOUT a_6369_n15507# VDD.t16 VDD.t15 sky130_fd_pr__pfet_01v8_hvt ad=0.135 pd=1.27 as=0.26 ps=2.52 w=1 l=0.15
X65 VSS.t75 VDD.t60 VSS.t74 VSS.t73 sky130_fd_pr__nfet_01v8 ad=0.143 pd=1.62 as=0 ps=0 w=0.55 l=0.59
X66 x2.Y PWM_IN VDD.t40 VDD.t39 sky130_fd_pr__pfet_01v8_hvt ad=0.26 pd=2.52 as=0.26 ps=2.52 w=1 l=0.15
X67 XR2.R1 XR8.R1 VSS.t78 sky130_fd_pr__res_xhigh_po_0p35 l=30
X68 VSS.t37 XR5.R1 VSS.t36 sky130_fd_pr__res_xhigh_po_0p35 l=20
X69 x2.Y PWM_IN VSS.t55 VSS.t54 sky130_fd_pr__nfet_01v8 ad=0.169 pd=1.82 as=0.169 ps=1.82 w=0.65 l=0.15
X70 VDD.t45 CLK x1.x4.Y.t6 VDD.t46 sky130_fd_pr__pfet_01v8_hvt ad=0.14 pd=1.28 as=0.14 ps=1.28 w=1 l=0.15
X71 XR2.R1 VSS.t5 sky130_fd_pr__cap_mim_m3_1 l=10 w=10
X72 a_6761_n15097# a_6369_n15507# VDD.t14 VDD.t13 sky130_fd_pr__pfet_01v8_hvt ad=0.0882 pd=0.84 as=0.1113 ps=1.37 w=0.42 l=0.15
X73 VDD.t38 VSS.t84 VDD.t37 VDD.t36 sky130_fd_pr__pfet_01v8_hvt ad=0.2262 pd=2.26 as=0 ps=0 w=0.87 l=0.59
X74 VDD.t43 CLK x1.x4.Y.t4 VDD.t42 sky130_fd_pr__pfet_01v8_hvt ad=0.305 pd=2.61 as=0.14 ps=1.28 w=1 l=0.15
X75 a_3988_n14929# x1.x2.VLAT_PLUS a_4014_n15531# VSS.t1 sky130_fd_pr__nfet_01v8 ad=0.29 pd=2.58 as=0.29 ps=2.58 w=1 l=0.15
X76 VIN.t1 x1.VINP sky130_fd_pr__cap_mim_m3_1 l=10 w=10
X77 x1.x4.Y.t3 CLK VSS.t62 VSS.t61 sky130_fd_pr__nfet_01v8 ad=0.0588 pd=0.7 as=0.1659 ps=1.63 w=0.42 l=0.15
X78 VIN.t5 x1.VINP sky130_fd_pr__cap_mim_m3_1 l=10 w=10
X79 VSS.t69 VDD.t62 VSS.t68 VSS.t67 sky130_fd_pr__nfet_01v8 ad=0.143 pd=1.62 as=0 ps=0 w=0.55 l=0.59
X80 XR2.R1 VSS.t5 sky130_fd_pr__cap_mim_m3_1 l=10 w=10
X81 VIN.t2 x1.VINP sky130_fd_pr__cap_mim_m3_1 l=10 w=10
X82 VSS.t28 x1.x3.D a_6395_n14501# VSS.t27 sky130_fd_pr__nfet_01v8 ad=0.1092 pd=1.36 as=0.0813 ps=0.83 w=0.42 l=0.15
X83 VIN.t0 x1.VINP sky130_fd_pr__cap_mim_m3_1 l=10 w=10
X84 VDD.t9 x1.x3.D a_6395_n14501# VDD.t8 sky130_fd_pr__pfet_01v8_hvt ad=0.1092 pd=1.36 as=0.05775 ps=0.695 w=0.42 l=0.15
X85 XR2.R1 VSS.t5 sky130_fd_pr__cap_mim_m3_1 l=10 w=10
X86 a_6761_n14672# a_6369_n14729# VDD.t18 VDD.t17 sky130_fd_pr__pfet_01v8_hvt ad=0.07665 pd=0.785 as=0.17887 ps=1.26 w=0.42 l=0.15
X87 XR2.R1 VSS.t5 sky130_fd_pr__cap_mim_m3_1 l=10 w=10
X88 XR1.R2 x2.Y VDD.t59 VDD.t4 sky130_fd_pr__pfet_01v8_hvt ad=0.26 pd=2.52 as=0.26 ps=2.52 w=1 l=0.15
X89 a_4014_n15531# x1.x2.VLAT_MINUS a_3988_n15877# VSS.t1 sky130_fd_pr__nfet_01v8 ad=0.29 pd=2.58 as=0.29 ps=2.58 w=1 l=0.15
X90 a_n52_n14940# x1.x2.VLAT_MINUS x1.x2.VLAT_PLUS VSS.t0 sky130_fd_pr__nfet_01v8 ad=0.29 pd=2.58 as=0.29 ps=2.58 w=1 l=0.15
X91 VIN.t4 x1.VINP sky130_fd_pr__cap_mim_m3_1 l=10 w=10
X92 XR1.R2 x2.Y VSS.t81 VSS.t80 sky130_fd_pr__nfet_01v8 ad=0.169 pd=1.82 as=0.169 ps=1.82 w=0.65 l=0.15
X93 VIN.t2 x1.VINP sky130_fd_pr__cap_mim_m3_1 l=10 w=10
X94 a_n114_n15681# XR2.R1 a_n52_n16427# VSS.t2 sky130_fd_pr__nfet_01v8_lvt ad=0.725 pd=5.29 as=1.45 ps=10.58 w=5 l=1
X95 VIN.t6 x1.VINP sky130_fd_pr__cap_mim_m3_1 l=10 w=10
X96 VIN.t1 x1.VINP sky130_fd_pr__cap_mim_m3_1 l=10 w=10
X97 a_6369_n14729# a_6369_n15055# a_6369_n15339# VDD.t22 sky130_fd_pr__pfet_01v8_hvt ad=0.1095 pd=1.075 as=0.0567 ps=0.69 w=0.42 l=0.15
X98 a_6369_n15339# a_6369_n14949# a_6761_n15097# VDD.t32 sky130_fd_pr__pfet_01v8_hvt ad=0.0567 pd=0.69 as=0.0882 ps=0.84 w=0.42 l=0.15
X99 VDD.t48 CLK x1.x4.Y.t8 VDD.t49 sky130_fd_pr__pfet_01v8_hvt ad=0.14 pd=1.28 as=0.14 ps=1.28 w=1 l=0.15
X100 VIN.t1 x1.VINP sky130_fd_pr__cap_mim_m3_1 l=10 w=10
X101 VDD.t11 a_6369_n15507# VOUT VDD.t12 sky130_fd_pr__pfet_01v8_hvt ad=0.135 pd=1.27 as=0.135 ps=1.27 w=1 l=0.15
X102 VDD.t23 a_3988_n15877# x1.x3.D VDD.t2 sky130_fd_pr__pfet_01v8 ad=0.29 pd=2.58 as=0.29 ps=2.58 w=1 l=0.15
X103 XR2.R1 VSS.t5 sky130_fd_pr__cap_mim_m3_1 l=10 w=10
X104 VIN.t3 x1.VINP sky130_fd_pr__cap_mim_m3_1 l=10 w=10
X105 VDD.t1 x1.x4.Y.t19 a_n52_n14940# VDD.t52 sky130_fd_pr__pfet_01v8 ad=1.55 pd=10.62 as=0.825 ps=5.33 w=5 l=0.15
X106 x1.x2.VLAT_MINUS x1.x2.VLAT_PLUS a_n52_n16427# VSS.t49 sky130_fd_pr__nfet_01v8 ad=0.29 pd=2.58 as=0.29 ps=2.58 w=1 l=0.15
X107 VIN.t0 x1.VINP sky130_fd_pr__cap_mim_m3_1 l=10 w=10
X108 a_6369_n15507# a_6369_n15339# VDD.t11 VDD.t10 sky130_fd_pr__pfet_01v8_hvt ad=0.27 pd=2.54 as=0.135 ps=1.27 w=1 l=0.15
X109 VDD.t18 a_6369_n14848# a_6369_n14729# VDD.t27 sky130_fd_pr__pfet_01v8_hvt ad=0.17887 pd=1.26 as=0.1095 ps=1.075 w=0.75 l=0.15
X110 a_6369_n14848# a_6369_n15055# a_6761_n14672# VDD.t21 sky130_fd_pr__pfet_01v8_hvt ad=0.06825 pd=0.745 as=0.07665 ps=0.785 w=0.42 l=0.15
X111 VIN.t7 x1.VINP sky130_fd_pr__cap_mim_m3_1 l=10 w=10
X112 XR1.R1 XR1.R2 VSS.t40 sky130_fd_pr__res_xhigh_po_0p35 l=30
X113 a_n52_n14940# x1.x4.Y.t18 VDD.t1 VDD.t52 sky130_fd_pr__pfet_01v8 ad=0.825 pd=5.33 as=1.55 ps=10.62 w=5 l=0.15
X114 VIN.t0 x1.VINP sky130_fd_pr__cap_mim_m3_1 l=10 w=10
X115 XR3.R1 VDD.t7 VSS.t26 sky130_fd_pr__res_xhigh_po_0p35 l=20
X116 VSS.t42 a_6369_n15055# a_6369_n14949# VSS.t41 sky130_fd_pr__nfet_01v8 ad=0.0567 pd=0.69 as=0.1092 ps=1.36 w=0.42 l=0.15
X117 VSS.t72 VDD.t61 VSS.t71 VSS.t70 sky130_fd_pr__nfet_01v8 ad=0.143 pd=1.62 as=0 ps=0 w=0.55 l=0.59
X118 VOUT a_6369_n15507# VSS.t33 VSS.t32 sky130_fd_pr__nfet_01v8 ad=0.08775 pd=0.92 as=0.169 ps=1.82 w=0.65 l=0.15
X119 a_3988_n14929# x1.x2.VLAT_PLUS a_4729_n15534# VDD.t2 sky130_fd_pr__pfet_01v8 ad=0.29 pd=2.58 as=0.29 ps=2.58 w=1 l=0.15
X120 VSS.t60 CLK x1.x4.Y.t2 VSS.t63 sky130_fd_pr__nfet_01v8 ad=0.0588 pd=0.7 as=0.0588 ps=0.7 w=0.42 l=0.15
X121 a_6395_n15120# a_6369_n15507# VSS.t35 VSS.t34 sky130_fd_pr__nfet_01v8 ad=0.066 pd=0.745 as=0.1092 ps=1.36 w=0.42 l=0.15
R0 VIN VIN.t7 41.608
R1 VIN.t5 VIN.t4 1.70788
R2 VIN.t6 VIN.t2 1.41957
R3 VIN.t5 VIN.t1 1.41957
R4 VIN.t7 VIN.t3 1.41696
R5 VIN.t6 VIN.t5 1.3487
R6 VIN.t7 VIN.t6 1.34609
R7 VIN.t4 VIN.t0 1.06039
R8 VDD.n134 VDD.n77 3031.76
R9 VDD.n136 VDD.n75 3031.76
R10 VDD.n100 VDD.n75 3031.76
R11 VDD.n113 VDD.n82 3031.76
R12 VDD.n119 VDD.n92 3031.76
R13 VDD.n109 VDD.n92 3031.76
R14 VDD.n97 VDD.n78 2350.59
R15 VDD.n78 VDD.n76 2350.59
R16 VDD.n111 VDD.n89 2350.59
R17 VDD.n111 VDD.n108 2350.59
R18 VDD.n87 VDD.n80 1630.59
R19 VDD.n122 VDD.n88 1630.59
R20 VDD.n53 VDD.n26 1312.94
R21 VDD.n70 VDD.n26 1312.94
R22 VDD.n61 VDD.n35 1312.94
R23 VDD.n61 VDD.n29 1312.94
R24 VDD.n98 VDD.n87 1298.82
R25 VDD.n122 VDD.n121 1298.82
R26 VDD.n42 VDD.n37 815.294
R27 VDD.n37 VDD.n31 815.294
R28 VDD.n59 VDD.n39 815.294
R29 VDD.n59 VDD.n30 815.294
R30 VDD.n54 VDD.n36 815.294
R31 VDD.n36 VDD.n27 815.294
R32 VDD.n129 VDD.n84 815.294
R33 VDD.n130 VDD.n129 815.294
R34 VDD.n21 VDD.t36 761.74
R35 VDD.t15 VDD.t28 739.875
R36 VDD.t36 VDD.t50 736.917
R37 VDD.n98 VDD.n97 681.178
R38 VDD.n77 VDD.n76 681.178
R39 VDD.n136 VDD.n76 681.178
R40 VDD.n100 VDD.n97 681.178
R41 VDD.n119 VDD.n89 681.178
R42 VDD.n121 VDD.n89 681.178
R43 VDD.n113 VDD.n108 681.178
R44 VDD.n109 VDD.n108 681.178
R45 VDD.n135 VDD.t52 668.817
R46 VDD.n112 VDD.t24 668.817
R47 VDD.t13 VDD.t10 621.495
R48 VDD.t19 VDD.t8 556.386
R49 VDD.t28 VDD.n24 544.548
R50 VDD.t33 VDD.t39 544.548
R51 VDD.t4 VDD.t33 544.548
R52 VDD.n86 VDD.n12 535.24
R53 VDD.n90 VDD.n12 535.24
R54 VDD.n42 VDD.n35 497.647
R55 VDD.n43 VDD.n42 497.647
R56 VDD.n43 VDD.n39 497.647
R57 VDD.n68 VDD.n31 497.647
R58 VDD.n68 VDD.n30 497.647
R59 VDD.n30 VDD.n28 497.647
R60 VDD.n28 VDD.n27 497.647
R61 VDD.n55 VDD.n39 497.647
R62 VDD.n55 VDD.n54 497.647
R63 VDD.n54 VDD.n53 497.647
R64 VDD.n70 VDD.n27 497.647
R65 VDD.n31 VDD.n29 497.647
R66 VDD.n123 VDD.n122 497.647
R67 VDD.n123 VDD.n84 497.647
R68 VDD.n125 VDD.n84 497.647
R69 VDD.n125 VDD.n87 497.647
R70 VDD.n132 VDD.n130 497.647
R71 VDD.n132 VDD.n80 497.647
R72 VDD.n88 VDD.n83 497.647
R73 VDD.n130 VDD.n83 497.647
R74 VDD.n24 VDD.t42 440.966
R75 VDD.n99 VDD.n79 407.717
R76 VDD.n120 VDD.n79 407.717
R77 VDD.t17 VDD.t27 390.654
R78 VDD.n124 VDD.t26 352.187
R79 VDD.n131 VDD.t0 352.187
R80 VDD.t32 VDD.t13 337.384
R81 VDD.n101 VDD.n73 323.389
R82 VDD.n118 VDD.n117 323.389
R83 VDD.t21 VDD.t17 304.829
R84 VDD.t27 VDD.t22 281.154
R85 VDD.t31 VDD.t21 281.154
R86 VDD.t52 VDD.n79 261.099
R87 VDD.t24 VDD.n79 261.099
R88 VDD.t50 VDD.t49 254.518
R89 VDD.t49 VDD.t47 254.518
R90 VDD.t47 VDD.t46 254.518
R91 VDD.t46 VDD.t44 254.518
R92 VDD.t44 VDD.t42 254.518
R93 VDD.t8 VDD.t31 251.559
R94 VDD.n103 VDD.n102 250.73
R95 VDD.n110 VDD.n93 250.73
R96 VDD.n138 VDD.n73 250.345
R97 VDD.n117 VDD.n116 250.148
R98 VDD.t12 VDD.t15 248.599
R99 VDD.t10 VDD.t12 248.599
R100 VDD.t22 VDD.t32 248.599
R101 VDD.t41 VDD.t19 248.599
R102 VDD.n104 VDD.n103 242.825
R103 VDD.n110 VDD.n107 242.825
R104 VDD.n24 VDD.n23 213.119
R105 VDD.n139 VDD.t4 213.119
R106 VDD.t39 VDD.n1 213.119
R107 VDD.n60 VDD.n38 160.183
R108 VDD.n62 VDD.n34 140.048
R109 VDD.n96 VDD.n86 138.542
R110 VDD.n91 VDD.n90 138.542
R111 VDD.n69 VDD.t2 135.22
R112 VDD.n52 VDD.n51 121.138
R113 VDD.n134 VDD.n80 102.353
R114 VDD.n88 VDD.n82 102.353
R115 VDD.n70 VDD.n69 92.5005
R116 VDD.n71 VDD.n70 92.5005
R117 VDD.n69 VDD.n28 92.5005
R118 VDD.n46 VDD.n28 92.5005
R119 VDD.n69 VDD.n68 92.5005
R120 VDD.n68 VDD.n67 92.5005
R121 VDD.n69 VDD.n29 92.5005
R122 VDD.n64 VDD.n29 92.5005
R123 VDD.n38 VDD.n35 92.5005
R124 VDD.n35 VDD.n34 92.5005
R125 VDD.n43 VDD.n38 92.5005
R126 VDD.n44 VDD.n43 92.5005
R127 VDD.n55 VDD.n38 92.5005
R128 VDD.n56 VDD.n55 92.5005
R129 VDD.n53 VDD.n38 92.5005
R130 VDD.n53 VDD.n52 92.5005
R131 VDD.n132 VDD.n131 92.5005
R132 VDD.n12 VDD.n132 92.5005
R133 VDD.n131 VDD.n83 92.5005
R134 VDD.n12 VDD.n83 92.5005
R135 VDD.n125 VDD.n124 92.5005
R136 VDD.n126 VDD.n125 92.5005
R137 VDD.n124 VDD.n123 92.5005
R138 VDD.n123 VDD.n85 92.5005
R139 VDD.n50 VDD.n49 86.9652
R140 VDD.n58 VDD.n57 86.9652
R141 VDD.n128 VDD.n127 86.9652
R142 VDD.n63 VDD.n62 82.0249
R143 VDD.n49 VDD.n48 80.5652
R144 VDD.n58 VDD.n32 80.5652
R145 VDD.n128 VDD.n12 80.5652
R146 VDD.n102 VDD.n101 72.6593
R147 VDD.n102 VDD.n96 72.6593
R148 VDD.n118 VDD.n93 72.6593
R149 VDD.n93 VDD.n91 72.6593
R150 VDD.n41 VDD.n40 68.0559
R151 VDD.t26 VDD.n79 65.0195
R152 VDD.t0 VDD.n79 65.0195
R153 VDD.n41 VDD.n34 53.0829
R154 VDD.n52 VDD.n50 53.0829
R155 VDD.n57 VDD.n56 53.0829
R156 VDD.n56 VDD.n50 53.0829
R157 VDD.n44 VDD.n41 53.0829
R158 VDD.n57 VDD.n44 53.0829
R159 VDD.n127 VDD.n126 53.0829
R160 VDD.n126 VDD.n86 53.0829
R161 VDD.n90 VDD.n85 53.0829
R162 VDD.n127 VDD.n85 53.0829
R163 VDD.n61 VDD.n60 46.2505
R164 VDD.n62 VDD.n61 46.2505
R165 VDD.n60 VDD.n37 46.2505
R166 VDD.n40 VDD.n37 46.2505
R167 VDD.n60 VDD.n59 46.2505
R168 VDD.n59 VDD.n58 46.2505
R169 VDD.n60 VDD.n36 46.2505
R170 VDD.n49 VDD.n36 46.2505
R171 VDD.n60 VDD.n26 46.2505
R172 VDD.n51 VDD.n26 46.2505
R173 VDD.n136 VDD.n135 46.2505
R174 VDD.n137 VDD.n136 46.2505
R175 VDD.n135 VDD.n77 46.2505
R176 VDD.n105 VDD.n77 46.2505
R177 VDD.n129 VDD.n79 46.2505
R178 VDD.n129 VDD.n128 46.2505
R179 VDD.n99 VDD.n98 46.2505
R180 VDD.n98 VDD.n96 46.2505
R181 VDD.n100 VDD.n99 46.2505
R182 VDD.n101 VDD.n100 46.2505
R183 VDD.n113 VDD.n112 46.2505
R184 VDD.n114 VDD.n113 46.2505
R185 VDD.n112 VDD.n109 46.2505
R186 VDD.n109 VDD.n94 46.2505
R187 VDD.n120 VDD.n119 46.2505
R188 VDD.n119 VDD.n118 46.2505
R189 VDD.n121 VDD.n120 46.2505
R190 VDD.n121 VDD.n91 46.2505
R191 VDD.t18 VDD.n7 8.97564
R192 VDD.n0 VDD.t11 4.57183
R193 VDD.t7 VDD.t14 5.3145
R194 VDD.n14 VDD.t48 5.63708
R195 VDD.t9 VDD.n7 8.21436
R196 VDD.n16 VDD.t45 30.3699
R197 VDD.t30 VDD.n10 5.6556
R198 VDD.n60 VDD.t2 24.964
R199 VDD.t45 VDD.n15 5.24939
R200 VDD.t41 VDD.n19 629.667
R201 VDD.n18 VDD.t20 5.1393
R202 VDD.t9 VDD.n18 26.9746
R203 VDD.t20 VDD.n19 26.6355
R204 VDD.n15 VDD.t48 26.3317
R205 VDD.n16 VDD.t43 4.76994
R206 VDD.n0 VDD.t16 25.3195
R207 VDD.n14 VDD.t51 22.2018
R208 VDD.t23 VDD.n33 14.4208
R209 VDD.n72 VDD.t3 14.4208
R210 VDD.t51 VDD.n13 4.03893
R211 VDD.n17 VDD.t29 4.03893
R212 VDD.t34 VDD.n139 14.2735
R213 VDD.t35 VDD.n1 14.2735
R214 VDD.n133 VDD.n81 14.2185
R215 VDD.n105 VDD.n104 13.8562
R216 VDD.n114 VDD.n107 13.8562
R217 VDD.n95 VDD.n94 13.3283
R218 VDD.n137 VDD.n74 13.2624
R219 VDD.n23 VDD.t43 12.8005
R220 VDD.t52 VDD.n134 10.8829
R221 VDD.n134 VDD.n133 10.8829
R222 VDD.t24 VDD.n82 10.8829
R223 VDD.n133 VDD.n82 10.8829
R224 VDD.t52 VDD.n78 10.8829
R225 VDD.n103 VDD.n78 10.8829
R226 VDD.t52 VDD.n75 10.8829
R227 VDD.n75 VDD.n73 10.8829
R228 VDD.t24 VDD.n92 10.8829
R229 VDD.n117 VDD.n92 10.8829
R230 VDD.t24 VDD.n111 10.8829
R231 VDD.n111 VDD.n110 10.8829
R232 VDD.t59 VDD.n8 17.7849
R233 VDD.t40 VDD.n3 8.74855
R234 VDD.n5 VDD.n72 10.5356
R235 VDD.t7 VDD.n3 10.3046
R236 VDD.n2 VDD.t5 9.72505
R237 VDD.n5 VDD.n63 9.5505
R238 VDD.t7 VDD.n19 2.06317
R239 VDD.n18 VDD.t7 2.08185
R240 VDD.n0 VDD.t7 1.36141
R241 VDD.n10 VDD.t7 1.97608
R242 VDD.t7 VDD.n20 9.3005
R243 VDD.t7 VDD.n17 2.63203
R244 VDD.n23 VDD.n17 4.03893
R245 VDD.t7 VDD.n16 2.26653
R246 VDD.n15 VDD.n6 2.02681
R247 VDD.n6 VDD.n14 1.83296
R248 VDD.n13 VDD.n6 2.63203
R249 VDD.n6 VDD.n22 9.3005
R250 VDD.n45 VDD.n5 9.3005
R251 VDD.n47 VDD.n5 9.3005
R252 VDD.n25 VDD.n5 9.3005
R253 VDD.n5 VDD.n65 9.3005
R254 VDD.n66 VDD.n5 9.3005
R255 VDD.t1 VDD.n138 9.3005
R256 VDD.t1 VDD.n106 9.3005
R257 VDD.n74 VDD.t1 9.3005
R258 VDD.n116 VDD.t25 9.3005
R259 VDD.t25 VDD.n95 9.3005
R260 VDD.t25 VDD.n115 9.3005
R261 VDD.n3 VDD.n1 6.96829
R262 VDD.n9 VDD.t35 1.86836
R263 VDD.n9 VDD.n3 3.71732
R264 VDD.t34 VDD.n3 9.3005
R265 VDD.n11 VDD.n139 5.1393
R266 VDD.n2 VDD.n11 2.08185
R267 VDD.n2 VDD.n8 0.369279
R268 VDD.n2 VDD.n140 9.3005
R269 VDD.n11 VDD.t59 13.4216
R270 VDD.n115 VDD.n81 7.45617
R271 VDD.n106 VDD.n81 7.39019
R272 VDD.n66 VDD.n33 6.77477
R273 VDD.n138 VDD.n137 6.33452
R274 VDD.n116 VDD.n94 6.33452
R275 VDD.n67 VDD.n32 5.91395
R276 VDD.n46 VDD.n45 5.53968
R277 VDD.n115 VDD.n114 5.27885
R278 VDD.n106 VDD.n105 5.21287
R279 VDD.n4 VDD.n81 4.86356
R280 VDD.n22 VDD.t38 4.36875
R281 VDD.n20 VDD.t30 4.36875
R282 VDD.n140 VDD.t6 4.36875
R283 VDD.n64 VDD.n63 4.34202
R284 VDD.t37 VDD.n21 4.33016
R285 VDD.n48 VDD.n47 3.96775
R286 VDD.n72 VDD.n71 3.85547
R287 VDD.n48 VDD.n25 3.51863
R288 VDD.n22 VDD.t62 3.50526
R289 VDD.n20 VDD.t63 3.50526
R290 VDD.n140 VDD.t60 3.50526
R291 VDD.n9 VDD.t61 5.37312
R292 VDD.n65 VDD.n64 3.14436
R293 VDD.n40 VDD.t23 2.91696
R294 VDD.n51 VDD.t3 2.91696
R295 VDD.n6 VDD.n21 2.76497
R296 VDD.n10 VDD.t16 7.98614
R297 VDD.n71 VDD.n25 2.39582
R298 VDD.n47 VDD.n46 1.9467
R299 VDD.n67 VDD.n66 1.19816
R300 VDD.t61 VDD.t34 1.16875
R301 VDD.t63 VDD.t29 1.16875
R302 VDD.t62 VDD.t37 0.863992
R303 VDD.t60 VDD.t5 0.863992
R304 VDD.t7 VDD.t1 0.759979
R305 VDD.n65 VDD.n33 0.711611
R306 VDD VDD.t7 0.648521
R307 VDD.n104 VDD.n74 0.594314
R308 VDD.n107 VDD.n95 0.528335
R309 VDD.n45 VDD.n32 0.374769
R310 VDD.n13 VDD.t38 4.3437
R311 VDD.n133 VDD.n12 0.671159
R312 VDD.t6 VDD.n8 7.13081
R313 VDD.n3 VDD.n2 1.61255
R314 VDD.t7 VDD.n5 1.38861
R315 VDD.t7 VDD.n6 1.32742
R316 VDD.n7 VDD.t7 1.32121
R317 VDD.t25 VDD.n4 1.17426
R318 VDD.n4 VDD.t1 1.1727
R319 VSS.n211 VSS.n22 21206.5
R320 VSS.n211 VSS.n21 21206.5
R321 VSS.n193 VSS.n40 21206.5
R322 VSS.n192 VSS.n40 21206.5
R323 VSS.n195 VSS.n38 20348.9
R324 VSS.n195 VSS.n36 20348.9
R325 VSS.n33 VSS.n26 20348.9
R326 VSS.n33 VSS.n30 20348.9
R327 VSS.n31 VSS.n27 20348.9
R328 VSS.n32 VSS.n31 20348.9
R329 VSS.n65 VSS.n63 15412.4
R330 VSS.n83 VSS.n43 15412.4
R331 VSS.n83 VSS.n42 15412.4
R332 VSS.n78 VSS.n48 14554.8
R333 VSS.n78 VSS.n47 14554.8
R334 VSS.n57 VSS.n56 14554.8
R335 VSS.n56 VSS.n51 14554.8
R336 VSS.n60 VSS.n58 14554.8
R337 VSS.n60 VSS.n54 14554.8
R338 VSS.n130 VSS.n85 6232.79
R339 VSS.n167 VSS.n144 5684.03
R340 VSS.n154 VSS.n144 5684.03
R341 VSS.n169 VSS.n140 5684.03
R342 VSS.n140 VSS.n139 5684.03
R343 VSS.n181 VSS.n41 5676.83
R344 VSS.n158 VSS.n142 3425.61
R345 VSS.n158 VSS.n157 3425.61
R346 VSS.n160 VSS.n145 3333.03
R347 VSS.n160 VSS.n148 3333.03
R348 VSS.t54 VSS.n212 2535.96
R349 VSS.n41 VSS.t73 2403.66
R350 VSS.n127 VSS.n89 2126.44
R351 VSS.n97 VSS.n89 2126.44
R352 VSS.n101 VSS.n87 2126.44
R353 VSS.n113 VSS.n101 2126.44
R354 VSS.n151 VSS.n132 2126.44
R355 VSS.n179 VSS.n132 2126.44
R356 VSS.n173 VSS.n136 2126.44
R357 VSS.n173 VSS.n131 2126.44
R358 VSS.n157 VSS.n156 2056.91
R359 VSS.n169 VSS.n142 2056.91
R360 VSS.n143 VSS.n142 2056.91
R361 VSS.n157 VSS.n139 2056.91
R362 VSS.n167 VSS.n145 2039.53
R363 VSS.n156 VSS.n148 2039.53
R364 VSS.n154 VSS.n148 2039.53
R365 VSS.n145 VSS.n143 2039.53
R366 VSS.n210 VSS.n209 1377.88
R367 VSS.n210 VSS.n23 1377.88
R368 VSS.n194 VSS.n39 1377.88
R369 VSS.n191 VSS.n39 1377.88
R370 VSS.n197 VSS.n196 1322.16
R371 VSS.n196 VSS.n35 1322.16
R372 VSS.n34 VSS.n25 1322.16
R373 VSS.n202 VSS.n34 1322.16
R374 VSS.n208 VSS.n24 1322.16
R375 VSS.n203 VSS.n24 1322.16
R376 VSS.n123 VSS.n90 1309.47
R377 VSS.n123 VSS.n94 1309.47
R378 VSS.n121 VSS.n103 1309.47
R379 VSS.n121 VSS.n102 1309.47
R380 VSS.n100 VSS.n99 1309.47
R381 VSS.n112 VSS.n100 1309.47
R382 VSS.n175 VSS.n135 1272.06
R383 VSS.n175 VSS.n133 1272.06
R384 VSS.n188 VSS.n187 1205.01
R385 VSS.n217 VSS.n20 1198.25
R386 VSS.n214 VSS.n213 1198.25
R387 VSS.n184 VSS.n183 1198.25
R388 VSS.n85 VSS.n84 1127.21
R389 VSS.n68 VSS.n62 1001.41
R390 VSS.n64 VSS.n62 1001.41
R391 VSS.n82 VSS.n81 1001.41
R392 VSS.n82 VSS.n44 1001.41
R393 VSS.n80 VSS.n79 945.694
R394 VSS.n79 VSS.n46 945.694
R395 VSS.n59 VSS.n52 945.694
R396 VSS.n74 VSS.n52 945.694
R397 VSS.n69 VSS.n61 945.694
R398 VSS.n61 VSS.n53 945.694
R399 VSS.n67 VSS.n58 857.529
R400 VSS.n71 VSS.n58 857.529
R401 VSS.n71 VSS.n57 857.529
R402 VSS.n57 VSS.n50 857.529
R403 VSS.n50 VSS.n48 857.529
R404 VSS.n48 VSS.n43 857.529
R405 VSS.n65 VSS.n54 857.529
R406 VSS.n72 VSS.n54 857.529
R407 VSS.n72 VSS.n51 857.529
R408 VSS.n76 VSS.n51 857.529
R409 VSS.n76 VSS.n47 857.529
R410 VSS.n47 VSS.n42 857.529
R411 VSS.n27 VSS.n22 857.529
R412 VSS.n206 VSS.n27 857.529
R413 VSS.n206 VSS.n26 857.529
R414 VSS.n199 VSS.n26 857.529
R415 VSS.n199 VSS.n38 857.529
R416 VSS.n193 VSS.n38 857.529
R417 VSS.n32 VSS.n21 857.529
R418 VSS.n205 VSS.n32 857.529
R419 VSS.n205 VSS.n30 857.529
R420 VSS.n200 VSS.n30 857.529
R421 VSS.n200 VSS.n36 857.529
R422 VSS.n192 VSS.n36 857.529
R423 VSS.n103 VSS.n86 816.971
R424 VSS.n90 VSS.n86 816.971
R425 VSS.n127 VSS.n90 816.971
R426 VSS.n97 VSS.n94 816.971
R427 VSS.n112 VSS.n111 816.971
R428 VSS.n111 VSS.n102 816.971
R429 VSS.n104 VSS.n102 816.971
R430 VSS.n104 VSS.n94 816.971
R431 VSS.n99 VSS.n87 816.971
R432 VSS.n99 VSS.n88 816.971
R433 VSS.n103 VSS.n88 816.971
R434 VSS.n113 VSS.n112 816.971
R435 VSS.n136 VSS.n135 816.971
R436 VSS.n151 VSS.n135 816.971
R437 VSS.n179 VSS.n133 816.971
R438 VSS.n133 VSS.n131 816.971
R439 VSS.n122 VSS.n98 725.84
R440 VSS.t32 VSS.t64 712.273
R441 VSS.n128 VSS.t1 626.278
R442 VSS.t34 VSS.t29 542.821
R443 VSS.n183 VSS.t64 528.46
R444 VSS.n183 VSS.n182 436.555
R445 VSS.n190 VSS.n189 426.606
R446 VSS.n189 VSS.n41 384.192
R447 VSS.t61 VSS.t67 365.877
R448 VSS.t38 VSS.t50 341.776
R449 VSS.n182 VSS.n128 340.438
R450 VSS.t53 VSS.t44 304.44
R451 VSS.t73 VSS.t80 295.979
R452 VSS.n180 VSS.n179 292.5
R453 VSS.n179 VSS.n178 292.5
R454 VSS.n180 VSS.n131 292.5
R455 VSS.n5 VSS.n131 292.5
R456 VSS.n152 VSS.n136 292.5
R457 VSS.n137 VSS.n136 292.5
R458 VSS.n152 VSS.n151 292.5
R459 VSS.n151 VSS.n150 292.5
R460 VSS.n21 VSS.t40 292.5
R461 VSS.n23 VSS.n21 292.5
R462 VSS.t48 VSS.n205 292.5
R463 VSS.n205 VSS.n204 292.5
R464 VSS.n200 VSS.t51 292.5
R465 VSS.n201 VSS.n200 292.5
R466 VSS.t78 VSS.n192 292.5
R467 VSS.n192 VSS.n191 292.5
R468 VSS.n193 VSS.t78 292.5
R469 VSS.n194 VSS.n193 292.5
R470 VSS.t51 VSS.n199 292.5
R471 VSS.n199 VSS.n198 292.5
R472 VSS.n206 VSS.t48 292.5
R473 VSS.n207 VSS.n206 292.5
R474 VSS.n22 VSS.t40 292.5
R475 VSS.n209 VSS.n22 292.5
R476 VSS.n98 VSS.n97 292.5
R477 VSS.n97 VSS.n96 292.5
R478 VSS.n104 VSS.n98 292.5
R479 VSS.n105 VSS.n104 292.5
R480 VSS.n111 VSS.n98 292.5
R481 VSS.n111 VSS.n110 292.5
R482 VSS.n113 VSS.n98 292.5
R483 VSS.n114 VSS.n113 292.5
R484 VSS.n128 VSS.n87 292.5
R485 VSS.n116 VSS.n87 292.5
R486 VSS.n128 VSS.n88 292.5
R487 VSS.n118 VSS.n88 292.5
R488 VSS.n128 VSS.n86 292.5
R489 VSS.n107 VSS.n86 292.5
R490 VSS.n128 VSS.n127 292.5
R491 VSS.n127 VSS.n126 292.5
R492 VSS.t26 VSS.n65 292.5
R493 VSS.n65 VSS.n64 292.5
R494 VSS.n72 VSS.t45 292.5
R495 VSS.n73 VSS.n72 292.5
R496 VSS.t46 VSS.n76 292.5
R497 VSS.n76 VSS.n75 292.5
R498 VSS.n42 VSS.t36 292.5
R499 VSS.n44 VSS.n42 292.5
R500 VSS.n43 VSS.t36 292.5
R501 VSS.n81 VSS.n43 292.5
R502 VSS.t46 VSS.n50 292.5
R503 VSS.n50 VSS.n45 292.5
R504 VSS.t45 VSS.n71 292.5
R505 VSS.n71 VSS.n70 292.5
R506 VSS.n68 VSS.n67 292.5
R507 VSS.t50 VSS.t53 290.079
R508 VSS.n172 VSS.n171 286.361
R509 VSS.n67 VSS.n66 286.079
R510 VSS.t44 VSS.t34 272.846
R511 VSS.n166 VSS.n146 247.239
R512 VSS.n171 VSS.n170 247.195
R513 VSS.t31 VSS.t32 241.254
R514 VSS.t29 VSS.t31 241.254
R515 VSS.n6 VSS.n138 239.571
R516 VSS.n153 VSS.n146 237.53
R517 VSS.t27 VSS.t41 236.885
R518 VSS.n141 VSS.n138 216.534
R519 VSS.n165 VSS.n161 210.681
R520 VSS.n161 VSS.n147 210.681
R521 VSS.n168 VSS.t76 210.298
R522 VSS.n155 VSS.t2 210.298
R523 VSS.n213 VSS.t54 199.464
R524 VSS.n213 VSS.t70 197.32
R525 VSS.t70 VSS.n20 197.32
R526 VSS.t80 VSS.n20 191.958
R527 VSS.n174 VSS.n132 146.25
R528 VSS.n134 VSS.n132 146.25
R529 VSS.n174 VSS.n173 146.25
R530 VSS.n175 VSS.n174 146.25
R531 VSS.n176 VSS.n175 146.25
R532 VSS.n122 VSS.n89 146.25
R533 VSS.n95 VSS.n89 146.25
R534 VSS.n122 VSS.n101 146.25
R535 VSS.n115 VSS.n101 146.25
R536 VSS.n122 VSS.n100 146.25
R537 VSS.n108 VSS.n100 146.25
R538 VSS.n122 VSS.n121 146.25
R539 VSS.n121 VSS.n120 146.25
R540 VSS.n123 VSS.n122 146.25
R541 VSS.n124 VSS.n123 146.25
R542 VSS.t43 VSS.t27 141.124
R543 VSS.n115 VSS.n114 138.166
R544 VSS.n178 VSS.n134 138.166
R545 VSS.n6 VSS.n5 132.518
R546 VSS.t52 VSS.t43 124.743
R547 VSS.n168 VSS.n41 120.171
R548 VSS.n96 VSS.n95 117.778
R549 VSS.n182 VSS.t52 114.662
R550 VSS.t63 VSS.t61 108.362
R551 VSS.t59 VSS.t63 108.362
R552 VSS.t57 VSS.t59 108.362
R553 VSS.n182 VSS.t57 104.582
R554 VSS.n181 VSS.n130 104.213
R555 VSS.n122 VSS.t1 99.5625
R556 VSS.n150 VSS.n149 98.6537
R557 VSS.n124 VSS.n93 85.0829
R558 VSS.n120 VSS.n106 85.0829
R559 VSS.n116 VSS.n115 84.8269
R560 VSS.n177 VSS.n176 82.6519
R561 VSS.n125 VSS.n124 78.6829
R562 VSS.n120 VSS.n119 78.6829
R563 VSS.n173 VSS.n7 151.323
R564 VSS.n176 VSS.n8 76.4348
R565 VSS.n152 VSS.t49 68.9217
R566 VSS.n180 VSS.t0 68.9217
R567 VSS.n155 VSS.n154 65.0005
R568 VSS.n154 VSS.n153 65.0005
R569 VSS.n156 VSS.n155 65.0005
R570 VSS.n156 VSS.n8 65.0005
R571 VSS.n155 VSS.n139 65.0005
R572 VSS.n172 VSS.n139 65.0005
R573 VSS.n169 VSS.n168 65.0005
R574 VSS.n170 VSS.n169 65.0005
R575 VSS.n168 VSS.n143 65.0005
R576 VSS.n163 VSS.n143 65.0005
R577 VSS.n168 VSS.n167 65.0005
R578 VSS.n167 VSS.n166 65.0005
R579 VSS.n109 VSS.n108 64.6963
R580 VSS.n69 VSS.n68 55.7181
R581 VSS.n70 VSS.n69 55.7181
R582 VSS.n70 VSS.n59 55.7181
R583 VSS.n59 VSS.n45 55.7181
R584 VSS.n80 VSS.n45 55.7181
R585 VSS.n81 VSS.n80 55.7181
R586 VSS.n64 VSS.n53 55.7181
R587 VSS.n73 VSS.n53 55.7181
R588 VSS.n74 VSS.n73 55.7181
R589 VSS.n75 VSS.n74 55.7181
R590 VSS.n75 VSS.n46 55.7181
R591 VSS.n46 VSS.n44 55.7181
R592 VSS.n209 VSS.n208 55.7181
R593 VSS.n208 VSS.n207 55.7181
R594 VSS.n207 VSS.n25 55.7181
R595 VSS.n198 VSS.n25 55.7181
R596 VSS.n198 VSS.n197 55.7181
R597 VSS.n197 VSS.n194 55.7181
R598 VSS.n203 VSS.n23 55.7181
R599 VSS.n204 VSS.n203 55.7181
R600 VSS.n204 VSS.n202 55.7181
R601 VSS.n202 VSS.n201 55.7181
R602 VSS.n201 VSS.n35 55.7181
R603 VSS.n191 VSS.n35 55.7181
R604 VSS.n106 VSS.n105 53.0829
R605 VSS.n105 VSS.n93 53.0829
R606 VSS.n96 VSS.n93 53.0829
R607 VSS.n114 VSS.n109 53.0829
R608 VSS.n110 VSS.n109 53.0829
R609 VSS.n110 VSS.n106 53.0829
R610 VSS.n177 VSS.n5 53.0829
R611 VSS.n178 VSS.n177 53.0829
R612 VSS.t56 VSS.n188 52.9117
R613 VSS.n66 VSS.n63 52.3341
R614 VSS.n212 VSS.t40 52.3099
R615 VSS.n29 VSS.t40 52.3099
R616 VSS.t48 VSS.n29 52.3099
R617 VSS.t48 VSS.n28 52.3099
R618 VSS.t51 VSS.n28 52.3099
R619 VSS.t51 VSS.n37 52.3099
R620 VSS.t78 VSS.n37 52.3099
R621 VSS.t78 VSS.n190 52.3099
R622 VSS.t67 VSS.n181 51.7652
R623 VSS.t26 VSS.n55 45.3835
R624 VSS.t45 VSS.n55 45.3835
R625 VSS.t45 VSS.n49 45.3835
R626 VSS.t46 VSS.n49 45.3835
R627 VSS.n77 VSS.t46 45.3835
R628 VSS.n77 VSS.t36 45.3835
R629 VSS.n84 VSS.t36 45.3835
R630 VSS.n189 VSS.t41 44.1013
R631 VSS.n171 VSS.n140 36.9526
R632 VSS.n159 VSS.n144 36.563
R633 VSS.n146 VSS.n144 36.563
R634 VSS.n159 VSS.n140 36.563
R635 VSS.n159 VSS.n158 36.563
R636 VSS.n158 VSS.n138 36.563
R637 VSS.n160 VSS.n159 36.563
R638 VSS.n161 VSS.n160 36.563
R639 VSS.n155 VSS.n152 32.5172
R640 VSS.n181 VSS.n180 32.5172
R641 VSS.n188 VSS.n85 31.9756
R642 VSS.n2 VSS.t35 4.65022
R643 VSS.t30 VSS.n15 5.77756
R644 VSS.n9 VSS.t62 6.9707
R645 VSS.t28 VSS.n1 35.2762
R646 VSS.n11 VSS.t60 5.45298
R647 VSS.n2 VSS.t30 32.0787
R648 VSS.t69 VSS.n9 7.27851
R649 VSS.t58 VSS.n13 30.4369
R650 VSS.t75 VSS.n3 7.27586
R651 VSS.n184 VSS.n13 5.21334
R652 VSS.t60 VSS.n12 28.3642
R653 VSS.n182 VSS.t38 22.977
R654 VSS.t42 VSS.n16 28.104
R655 VSS.n0 VSS.n2 1.38502
R656 VSS.n12 VSS.t58 5.02305
R657 VSS.n15 VSS.t33 25.7305
R658 VSS.n189 VSS.t56 18.6526
R659 VSS.n11 VSS.t62 23.9
R660 VSS.n149 VSS.n134 18.0711
R661 VSS.n170 VSS.n141 18.0171
R662 VSS.t25 VSS.n91 17.926
R663 VSS.n166 VSS.n165 17.9205
R664 VSS.n7 VSS.n137 18.9788
R665 VSS.n137 VSS.n8 16.0513
R666 VSS.n215 VSS.n214 14.8179
R667 VSS.n217 VSS.n10 14.8179
R668 VSS.n185 VSS.n184 14.8179
R669 VSS.n130 VSS.n18 1205.67
R670 VSS.n117 VSS.t47 14.4208
R671 VSS.n165 VSS.n164 11.0143
R672 VSS.n159 VSS.t76 10.9572
R673 VSS.n159 VSS.t2 10.9572
R674 VSS.n174 VSS.t49 10.9572
R675 VSS.n174 VSS.t0 10.9572
R676 VSS.n3 VSS.n4 1.16587
R677 VSS.n1 VSS.n0 0.551514
R678 VSS.n150 VSS.n8 16.1529
R679 VSS.n3 VSS.n17 3.61587
R680 VSS.n162 VSS.t77 9.55388
R681 VSS.n92 VSS.n19 9.5505
R682 VSS.n18 VSS.t37 2.58917
R683 VSS.n16 VSS.n0 2.08185
R684 VSS.t39 VSS.n1 5.11192
R685 VSS.n15 VSS.t37 1.76272
R686 VSS.t37 VSS.n14 1.95183
R687 VSS.t37 VSS.n129 9.3005
R688 VSS.n11 VSS.t37 1.92501
R689 VSS.t37 VSS.n12 2.13997
R690 VSS.n13 VSS.t37 2.04483
R691 VSS.t37 VSS.n185 9.3005
R692 VSS.n186 VSS.t37 9.3005
R693 VSS.t28 VSS.n16 5.1393
R694 VSS.n217 VSS.n4 5.91999
R695 VSS.n3 VSS.n10 9.3005
R696 VSS.n3 VSS.n216 9.3005
R697 VSS.n215 VSS.n3 9.3005
R698 VSS.n91 VSS.n19 9.3005
R699 VSS.n163 VSS.n162 9.22616
R700 VSS.n162 VSS.n141 8.79144
R701 VSS.n6 VSS.n172 8.48169
R702 VSS.n118 VSS.n117 8.38942
R703 VSS.n153 VSS.n147 8.25928
R704 VSS.n84 VSS.n83 8.1255
R705 VSS.n83 VSS.n82 8.1255
R706 VSS.n63 VSS.n62 8.1255
R707 VSS.n60 VSS.n55 8.1255
R708 VSS.n61 VSS.n60 8.1255
R709 VSS.n56 VSS.n49 8.1255
R710 VSS.n56 VSS.n52 8.1255
R711 VSS.n78 VSS.n77 8.1255
R712 VSS.n79 VSS.n78 8.1255
R713 VSS.n214 VSS.t55 6.94998
R714 VSS.t81 VSS.n4 6.66963
R715 VSS.n187 VSS.t42 6.49593
R716 VSS.n119 VSS.n118 6.22327
R717 VSS.n119 VSS.n107 6.22327
R718 VSS.n126 VSS.n125 6.22327
R719 VSS.t74 VSS.n17 2.32641
R720 VSS.n216 VSS.t71 5.98311
R721 VSS.n186 VSS.t65 5.98311
R722 VSS.n129 VSS.t68 5.98311
R723 VSS.n190 VSS.n40 5.79258
R724 VSS.n40 VSS.n39 5.79258
R725 VSS.n212 VSS.n211 5.79258
R726 VSS.n211 VSS.n210 5.79258
R727 VSS.n31 VSS.n29 5.79258
R728 VSS.n31 VSS.n24 5.79258
R729 VSS.n33 VSS.n28 5.79258
R730 VSS.n34 VSS.n33 5.79258
R731 VSS.n195 VSS.n37 5.79258
R732 VSS.n196 VSS.n195 5.79258
R733 VSS.n7 VSS.n6 0.211069
R734 VSS.n107 VSS.n92 5.1205
R735 VSS.n218 VSS.n3 5.0205
R736 VSS.n17 VSS.t82 7.02653
R737 VSS.n216 VSS.t83 4.8005
R738 VSS.t85 VSS.n186 4.8005
R739 VSS.n129 VSS.t84 4.8005
R740 VSS.n117 VSS.n116 4.05712
R741 VSS.n164 VSS.n163 3.58653
R742 VSS.n218 VSS.t3 3.4105
R743 VSS.n164 VSS.t77 3.11691
R744 VSS.t37 VSS.n19 2.72967
R745 VSS.n95 VSS.t25 2.51189
R746 VSS.n108 VSS.t47 2.51189
R747 VSS.t37 VSS.n218 2.3455
R748 VSS.t37 VSS.t77 2.15675
R749 VSS.n14 VSS.t33 7.2817
R750 VSS.t82 VSS.t75 1.18311
R751 VSS.t83 VSS.t72 1.18311
R752 VSS.t66 VSS.t85 1.18311
R753 VSS.t84 VSS.t69 1.18311
R754 VSS.n125 VSS.n92 1.10327
R755 VSS.n66 VSS.t26 0.994192
R756 VSS.n149 VSS.n147 0.868674
R757 VSS.n187 VSS.n0 0.65208
R758 VSS.n126 VSS.n91 0.551885
R759 VSS.t72 VSS.n215 0.417891
R760 VSS.t71 VSS.n10 0.417891
R761 VSS.n185 VSS.t65 0.417891
R762 VSS.n14 VSS.t66 5.81674
R763 VSS.n18 VSS.t68 4.54204
R764 VSS.n0 VSS.t37 1.8405
R765 VSS.t55 VSS.n3 1.75241
R766 VSS.n9 VSS.t37 1.62494
R767 VSS.t5 VSS.t3 1.50583
R768 VSS VSS.t37 1.31982
R769 x1.x4.Y.n12 x1.x4.Y.t16 1043.36
R770 x1.x4.Y.n13 x1.x4.Y.t13 1043.36
R771 x1.x4.Y.n12 x1.x4.Y.t18 1043.18
R772 x1.x4.Y.n13 x1.x4.Y.t11 1043.18
R773 x1.x4.Y.n0 x1.x4.Y.t10 1038.91
R774 x1.x4.Y.n1 x1.x4.Y.t19 1038.91
R775 x1.x4.Y.n0 x1.x4.Y.t12 1038.54
R776 x1.x4.Y.n1 x1.x4.Y.t17 1038.54
R777 x1.x4.Y.n3 x1.x4.Y.n2 312.226
R778 x1.x4.Y.n7 x1.x4.Y.n6 312.226
R779 x1.x4.Y.t8 x1.x4.Y.n16 311.849
R780 x1.x4.Y.n11 x1.x4.Y.t14 214.577
R781 x1.x4.Y.n11 x1.x4.Y.t15 214.577
R782 x1.x4.Y.n9 x1.x4.Y.n4 203.322
R783 x1.x4.Y.n8 x1.x4.Y.n5 202.97
R784 x1.x4.Y.n8 x1.x4.Y.n7 137.036
R785 x1.x4.Y.n10 x1.x4.Y.n9 51.9534
R786 x1.x4.Y.n7 x1.x4.Y.n3 45.5534
R787 x1.x4.Y.n16 x1.x4.Y.n3 45.177
R788 x1.x4.Y.n9 x1.x4.Y.n8 45.177
R789 x1.x4.Y.n5 x1.x4.Y.t1 40.0005
R790 x1.x4.Y.n5 x1.x4.Y.t0 40.0005
R791 x1.x4.Y.n4 x1.x4.Y.t3 40.0005
R792 x1.x4.Y.n4 x1.x4.Y.t2 40.0005
R793 x1.x4.Y.t9 x1.x4.Y.t8 27.5805
R794 x1.x4.Y.n2 x1.x4.Y.t7 27.5805
R795 x1.x4.Y.n2 x1.x4.Y.t6 27.5805
R796 x1.x4.Y.n6 x1.x4.Y.t5 27.5805
R797 x1.x4.Y.n6 x1.x4.Y.t4 27.5805
R798 x1.x4.Y.n15 x1.x4.Y 24.7107
R799 x1.x4.Y.n16 x1.x4.Y 23.4672
R800 x1.x4.Y x1.x4.Y.n10 12.5872
R801 x1.x4.Y x1.x4.Y.n15 10.8805
R802 x1.x4.Y x1.x4.Y.n14 8.47977
R803 x1.x4.Y x1.x4.Y.n11 8.23979
R804 x1.x4.Y.n1 x1.x4.Y.n12 5.9605
R805 x1.x4.Y.n0 x1.x4.Y.n13 5.9605
R806 x1.x4.Y.n15 x1.x4.Y 3.62717
R807 x1.x4.Y.n10 x1.x4.Y 1.9205
R808 x1.x4.Y.n14 x1.x4.Y.n1 1.19112
R809 x1.x4.Y.n14 x1.x4.Y.n0 1.17863
C0 VDD VOUT 0.37433f
C1 a_n52_n14940# x1.x2.VLAT_PLUS 0.37509f
C2 x1.x3.D x1.x4.Y 0.12921f
C3 a_6369_n15055# CLK 0.17402f
C4 a_3988_n15877# VDD 0.45502f
C5 a_n52_n14940# VDD 1.1851f
C6 VDD a_6369_n15339# 0.16095f
C7 x1.VINP XR3.R1 0.97358f
C8 x2.Y VDD 0.40744f
C9 XR1.R2 VDD 0.32774f
C10 x1.VINP VDD 3.02309f
C11 x1.x2.VLAT_PLUS x1.x4.Y 1.29683f
C12 a_3988_n14929# x1.x2.VLAT_PLUS 0.20676f
C13 a_6369_n14949# x1.x3.D 0.14329f
C14 x1.x4.Y a_n52_n16427# 0.46954f
C15 x1.x4.Y VDD 6.05624f
C16 a_3988_n14929# VDD 0.42147f
C17 a_6369_n14848# VDD 0.20138f
C18 x1.VINP a_n52_n14940# 0.73968f
C19 a_6369_n14729# VDD 0.14633f
C20 x1.VINP XR5.R1 0.73536f
C21 a_n52_n14940# x1.x4.Y 0.44393f
C22 XR2.R1 a_n52_n16427# 0.74162f
C23 XR2.R1 VDD 0.13279f
C24 a_6369_n15055# VDD 0.54305f
C25 a_6369_n14949# VDD 0.2676f
C26 XR1.R1 XR7.R1 0.61647f
C27 a_n114_n15681# a_n52_n16427# 0.67576f
C28 a_6369_n14949# a_6369_n15339# 0.11103f
C29 XR7.R1 XR8.R1 0.61647f
C30 a_6369_n14729# a_6369_n14848# 0.15954f
C31 VDD a_4729_n15534# 0.52477f
C32 a_4014_n15531# x1.x2.VLAT_PLUS 0.18707f
C33 x1.x2.VLAT_MINUS x1.x2.VLAT_PLUS 0.62877f
C34 a_n52_n14940# a_n114_n15681# 0.71601f
C35 VDD CLK 1.27278f
C36 x1.x2.VLAT_MINUS a_n52_n16427# 0.59227f
C37 x1.x2.VLAT_MINUS VDD 2.21619f
C38 VOUT CLK 0.22973f
C39 a_6369_n14848# a_6369_n15055# 0.16008f
C40 a_3988_n15877# x1.x2.VLAT_MINUS 0.22012f
C41 VIN VDD 0.33858f
C42 x1.x3.D VDD 0.87961f
C43 x1.VINP a_n114_n15681# 0.6295f
C44 x1.x4.Y a_n114_n15681# 0.70715f
C45 a_3988_n15877# x1.x3.D 0.12519f
C46 XR1.R1 VDD 0.11009f
C47 VDD PWM_IN 0.35665f
C48 a_3988_n14929# a_4729_n15534# 0.22518f
C49 VDD a_6369_n15507# 0.3741f
C50 a_6369_n14949# a_6369_n15055# 0.56881f
C51 x1.x4.Y CLK 0.55021f
C52 VOUT a_6369_n15507# 0.16556f
C53 x1.x2.VLAT_MINUS x1.x4.Y 1.3974f
C54 XR2.R1 a_n114_n15681# 0.62932f
C55 a_3988_n14929# a_4014_n15531# 0.22457f
C56 x1.x2.VLAT_PLUS VDD 2.83853f
C57 x1.VINP VIN 0.19647p
C58 a_6369_n15339# a_6369_n15507# 0.20625f
C59 VDD a_n52_n16427# 1.09956f
C60 VIN VSS 2.1911f
C61 VOUT VSS 2.02559f
C62 VDD VSS 2.5103f
C63 XR8.R1 VSS 3.793f
C64 XR7.R1 VSS 2.5134f
C65 XR1.R2 VSS 7.22677f
C66 XR1.R1 VSS 3.40472f
C67 a_4729_n15534# VSS 2.33032f
C68 a_n52_n16427# VSS 1.86005f
C69 a_4014_n15531# VSS 1.50068f
C70 a_6395_n14699# VSS 0.23863f
C71 a_6395_n14501# VSS 2.0119f
C72 x1.x3.D VSS 0.49011f
C73 x1.x4.Y VSS 7.55947f
C74 a_n114_n15681# VSS 76.7933f
C75 a_n52_n14940# VSS 75.8175f
C76 XR5.R1 VSS 2.49673f
C77 x1.VINP VSS 0.13724p
C78 XR3.R1 VSS 1.99416f
C79 x1.x4.Y.n0 VSS 0.50667f
C80 x1.x4.Y.n1 VSS 0.50829f
C81 x1.x4.Y.t0 VSS 1.59443f
C82 x1.x4.Y.n11 VSS 0.68684f
C83 x1.x4.Y.n12 VSS 0.96514f
C84 x1.x4.Y.n13 VSS 0.96514f
C85 x1.x4.Y.n14 VSS 0.25371f
C86 x1.x4.Y.n15 VSS 1.09615f
C87 VSS.t5 VSS 0.20959p
C88 VSS.t77 VSS 0.93066f
C89 VSS.t47 VSS 1.25985f
C90 VSS.t58 VSS 1.58849f
C91 VSS.t30 VSS 0.28339f
C92 VSS.t39 VSS 0.49649f
C93 VSS.t28 VSS 1.59088f
C94 VDD.t1 VSS 6.92149f
C95 VDD.t7 VSS 37.7687f
C96 VDD.n2 VSS 0.12855f
C97 VDD.n3 VSS 7.99146f
C98 VDD.n4 VSS 0.3305f
C99 VDD.t25 VSS 3.83915f
C100 VDD.n5 VSS 1.08933f
C101 VDD.n6 VSS 0.17934f
C102 VDD.n19 VSS 0.11505f
C103 VDD.t50 VSS 0.11237f
C104 VDD.t36 VSS 0.18202f
C105 VDD.n21 VSS 0.13252f
C106 VDD.n24 VSS 0.1219f
C107 VDD.t28 VSS 0.14558f
C108 VDD.t15 VSS 0.11204f
C109 VDD.t13 VSS 0.10868f
C110 VDD.t41 VSS 0.11435f
C111 VDD.t3 VSS 0.32489f
C112 VDD.t2 VSS 0.33071f
C113 VDD.n33 VSS 0.10087f
C114 VDD.n38 VSS 0.48246f
C115 VDD.t23 VSS 0.56891f
C116 VDD.n60 VSS 0.38225f
C117 VDD.n69 VSS 0.43092f
C118 VDD.n72 VSS 0.12106f
C119 VDD.n79 VSS 1.35634f
C120 VDD.n81 VSS 0.69072f
C121 VDD.t26 VSS 0.12697f
C122 VDD.n99 VSS 0.50614f
C123 VDD.t24 VSS 0.91541f
C124 VDD.n112 VSS 0.76317f
C125 VDD.n120 VSS 0.50614f
C126 VDD.n124 VSS 0.16545f
C127 VDD.t0 VSS 0.12697f
C128 VDD.n131 VSS 0.16545f
C129 VDD.n133 VSS 0.5382f
C130 VDD.t52 VSS 0.91541f
C131 VDD.n135 VSS 0.76317f
C132 VDD.t39 VSS 0.31276f
C133 VDD.t33 VSS 0.12344f
C134 VDD.t4 VSS 0.49524f
C135 VDD.t59 VSS 4.08176f
C136 VDD.t40 VSS 7.65068f
.ends
