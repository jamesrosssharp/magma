** sch_path: /home/jrsharp/code/magma/xschem/1bit_am/1bit_am.sch

.include /opt/pdk/sky130A/libs.ref/sky130_fd_sc_hd/spice/sky130_fd_sc_hd.spice

.subckt 1bit_am_routed VDD VSS CLK VIN VOUT PWM_IN
*.PININFO VDD:I VSS:I CLK:I VIN:I VOUT:O PWM_IN:I
x1 CLK NET_IN NET_PWM VDD VOUT VSS high_speed_comp_top
XR2 net2 NET_PWM net3 sky130_fd_pr__res_xhigh_po_0p35 L=30 mult=1 m=1
XR3 VDD net4 net5 sky130_fd_pr__res_xhigh_po_0p35 L=20 mult=1 m=1
XR4 net4 NET_IN net6 sky130_fd_pr__res_xhigh_po_0p35 L=20 mult=1 m=1
XR5 NET_IN net7 net8 sky130_fd_pr__res_xhigh_po_0p35 L=20 mult=1 m=1
XR6 net7 VSS net9 sky130_fd_pr__res_xhigh_po_0p35 L=20 mult=1 m=1
XC1 VIN NET_IN sky130_fd_pr__cap_mim_m3_1 W=10 L=10 m=20
XC2 NET_PWM VSS sky130_fd_pr__cap_mim_m3_1 W=10 L=10 m=20
x4 VSS VSS VDD VDD sky130_fd_sc_hd__decap_3
x5 VSS VSS VDD VDD sky130_fd_sc_hd__decap_3
x6 VSS VDD sky130_fd_sc_hd__tapvpwrvgnd_1
x7 VSS VDD sky130_fd_sc_hd__tapvpwrvgnd_1
XR1 net10 net11 net12 sky130_fd_pr__res_xhigh_po_0p35 L=30 mult=1 m=1
x3 PWM_IN VSS VSS VDD VDD net1 sky130_fd_sc_hd__inv_1
XR7 net11 net13 net14 sky130_fd_pr__res_xhigh_po_0p35 L=30 mult=1 m=1
XR8 net13 net2 net15 sky130_fd_pr__res_xhigh_po_0p35 L=30 mult=1 m=1
x2 net1 VSS VSS VDD VDD net10 sky130_fd_sc_hd__inv_1
.ends

* expanding   symbol:  /home/jrsharp/code/magma/xschem/flash_converter/high_speed_comp_top.sym # of
*+ pins=6
** sym_path: /home/jrsharp/code/magma/xschem/flash_converter/high_speed_comp_top.sym
** sch_path: /home/jrsharp/code/magma/xschem/flash_converter/high_speed_comp_top.sch
.subckt high_speed_comp_top CLK VINP VINN VDD COMP_OUT VSS
*.PININFO VINP:I VINN:I CLK:I COMP_OUT:O VDD:I VSS:I
x1 VDD CLK_PRIME net1 net2 VSS VINP VINN strong_arm_latch
x2 VDD net1 net2 VOUT VSS post_amplifier
x3 CLK VOUT VSS VSS VDD VDD COMP_OUT sky130_fd_sc_hd__dfxtp_2
x4 CLK VSS VSS VDD VDD CLK_PRIME sky130_fd_sc_hd__clkinv_4
x5 VSS VSS VDD VDD sky130_fd_sc_hd__decap_3
x7 VSS VSS VDD VDD sky130_fd_sc_hd__decap_3
x9 VSS VDD sky130_fd_sc_hd__tapvpwrvgnd_1
x6 VSS VDD sky130_fd_sc_hd__tapvpwrvgnd_1
x8 VSS VDD sky130_fd_sc_hd__tapvpwrvgnd_1
.ends

* expanding   symbol:  strong_arm_latch.sym # of pins=7
** sym_path: /home/jrsharp/code/magma/xschem/1bit_am/strong_arm_latch.sym
** sch_path: /home/jrsharp/code/magma/xschem/1bit_am/strong_arm_latch.sch
.subckt strong_arm_latch VDD CLK VOUT_PLUS VOUT_MINUS VSS VINP VINN
*.PININFO VSS:I VDD:I CLK:I VINP:I VINN:I VOUT_MINUS:O VOUT_PLUS:O
XM1 net2 VINP net1 VSS sky130_fd_pr__nfet_01v8_lvt L=1 W=5 nf=1 m=1
XM2 net3 VINN net1 VSS sky130_fd_pr__nfet_01v8_lvt L=1 W=5 nf=1 m=1
XM3 net1 CLK VSS VSS sky130_fd_pr__nfet_01v8_lvt L=1 W=5 nf=1 m=1
XM4 VOUT_PLUS VOUT_MINUS net2 VSS sky130_fd_pr__nfet_01v8 L=0.15 W=1 nf=1 m=1
XM5 VOUT_MINUS VOUT_PLUS net3 VSS sky130_fd_pr__nfet_01v8 L=0.15 W=1 nf=1 m=1
XM6 VOUT_PLUS VOUT_MINUS VDD VDD sky130_fd_pr__pfet_01v8 L=0.15 W=1 nf=1 m=1
XM7 VOUT_MINUS VOUT_PLUS VDD VDD sky130_fd_pr__pfet_01v8 L=0.15 W=1 nf=1 m=1
XM8 VOUT_PLUS CLK VDD VDD sky130_fd_pr__pfet_01v8 L=0.15 W=10 nf=1 m=1
XM9 net2 CLK VDD VDD sky130_fd_pr__pfet_01v8 L=0.15 W=10 nf=1 m=1
XM10 VOUT_MINUS CLK VDD VDD sky130_fd_pr__pfet_01v8 L=0.15 W=10 nf=1 m=1
XM11 net3 CLK VDD VDD sky130_fd_pr__pfet_01v8 L=0.15 W=10 nf=1 m=1
.ends

* expanding   symbol:  post_amplifier.sym # of pins=5
** sym_path: /home/jrsharp/code/magma/xschem/1bit_am/post_amplifier.sym
** sch_path: /home/jrsharp/code/magma/xschem/1bit_am/post_amplifier.sch
.subckt post_amplifier VDD VLAT_PLUS VLAT_MINUS VOUT VSS
*.PININFO VLAT_PLUS:I VLAT_MINUS:I VDD:I VSS:I VOUT:O
XM1 net1 VLAT_PLUS net4 VSS sky130_fd_pr__nfet_01v8 L=0.15 W=1 nf=1 m=1
XM2 net3 VLAT_MINUS net4 VSS sky130_fd_pr__nfet_01v8 L=0.15 W=1 nf=1 m=1
XM3 net4 net1 VSS VSS sky130_fd_pr__nfet_01v8 L=0.15 W=1 nf=1 m=1
XM4 net1 VLAT_PLUS net2 VDD sky130_fd_pr__pfet_01v8 L=0.15 W=1 nf=1 m=1
XM5 net3 VLAT_MINUS net2 VDD sky130_fd_pr__pfet_01v8 L=0.15 W=1 nf=1 m=1
XM6 net2 net1 VDD VDD sky130_fd_pr__pfet_01v8 L=0.15 W=1 nf=1 m=1
XM7 VOUT net3 VSS VSS sky130_fd_pr__nfet_01v8 L=0.15 W=1 nf=1 m=1
XM8 VOUT net3 VDD VDD sky130_fd_pr__pfet_01v8 L=0.15 W=1 nf=1 m=1
.ends

.end
